* Varredura Parametrica 3x3 de Ruido de Fonte (dVDD x dVSS) nas 7 Tuplas Polimorficas
.include "../00_modelo_ngspice/bp_ari_ngspice.lib"

.subckt POLY_NAND_NOR a b out rtop gtop rbot gbot
X1 out a rtop gtop gtop ARI W=1.0
X2 out b rtop gtop gtop ARI W=1.0
X3 out b n1   gbot gbot ARI W=2.0
X4 n1  a rbot gbot gbot ARI W=2.0
Cn1 n1 0 0.05f
.ends POLY_NAND_NOR

.subckt POLY_XOR a an b bn out rtop gtop rbot gbot
X1 out an rtop b  gtop ARI W=1.0
X2 out a  rtop bn gtop ARI W=1.0
X3 out a  rbot b  gbot ARI W=1.0
X4 out an rbot bn gbot ARI W=1.0
.ends POLY_XOR

.subckt BP_INV08 in out vdd_i vss
B_sh in_sh 0 V = (v(in) > 0.8 ? 0.8 : v(in)) - 0.27
Vg1p g1p 0 -0.7
Vg2p g2p 0 -0.4
Vg1n g1n 0 0.8
Vg2n g2n 0 0.8
XP out in_sh vdd_i g1p g2p ARI W=2.0
XN out in_sh vss   g1n g2n ARI W=1.0
Cout out 0 0.1f
.ends BP_INV08

.subckt BP_INV11 in out vdd11 vss
B_sh in_sh 0 V = v(in) - 0.27
Vg1p g1p 0 -0.4
Vg2p g2p 0 -0.1
Vg1n g1n 0 1.1
Vg2n g2n 0 0.8
XP out in_sh vdd11 g1p g2p ARI W=2.0
XN out in_sh vss   g1n g2n ARI W=1.0
Cout out 0 0.1f
.ends BP_INV11

.param mode_k = 0

* --- Alimentacoes e Entradas Bloco 2-Entradas (step = 7.0 ns/vetor, total = 252 ns) ---
Vdd08_2 vdd08_2 0 pwl(
+ 0.00n 0.72000 6.92n 0.72000
+ 7.00n 0.72000 13.92n 0.72000
+ 14.00n 0.72000 20.92n 0.72000
+ 21.00n 0.72000 27.92n 0.72000
+ 28.00n 0.72000 34.92n 0.72000
+ 35.00n 0.72000 41.92n 0.72000
+ 42.00n 0.72000 48.92n 0.72000
+ 49.00n 0.72000 55.92n 0.72000
+ 56.00n 0.72000 62.92n 0.72000
+ 63.00n 0.72000 69.92n 0.72000
+ 70.00n 0.72000 76.92n 0.72000
+ 77.00n 0.72000 83.92n 0.72000
+ 84.00n 0.80000 90.92n 0.80000
+ 91.00n 0.80000 97.92n 0.80000
+ 98.00n 0.80000 104.92n 0.80000
+ 105.00n 0.80000 111.92n 0.80000
+ 112.00n 0.80000 118.92n 0.80000
+ 119.00n 0.80000 125.92n 0.80000
+ 126.00n 0.80000 132.92n 0.80000
+ 133.00n 0.80000 139.92n 0.80000
+ 140.00n 0.80000 146.92n 0.80000
+ 147.00n 0.80000 153.92n 0.80000
+ 154.00n 0.80000 160.92n 0.80000
+ 161.00n 0.80000 167.92n 0.80000
+ 168.00n 0.88000 174.92n 0.88000
+ 175.00n 0.88000 181.92n 0.88000
+ 182.00n 0.88000 188.92n 0.88000
+ 189.00n 0.88000 195.92n 0.88000
+ 196.00n 0.88000 202.92n 0.88000
+ 203.00n 0.88000 209.92n 0.88000
+ 210.00n 0.88000 216.92n 0.88000
+ 217.00n 0.88000 223.92n 0.88000
+ 224.00n 0.88000 230.92n 0.88000
+ 231.00n 0.88000 237.92n 0.88000
+ 238.00n 0.88000 244.92n 0.88000
+ 245.00n 0.88000 251.92n 0.88000
+ 252.00n 0.88000)
Vdd15_2 vdd15_2 0 pwl(
+ 0.00n 1.35000 6.92n 1.35000
+ 7.00n 1.35000 13.92n 1.35000
+ 14.00n 1.35000 20.92n 1.35000
+ 21.00n 1.35000 27.92n 1.35000
+ 28.00n 1.35000 34.92n 1.35000
+ 35.00n 1.35000 41.92n 1.35000
+ 42.00n 1.35000 48.92n 1.35000
+ 49.00n 1.35000 55.92n 1.35000
+ 56.00n 1.35000 62.92n 1.35000
+ 63.00n 1.35000 69.92n 1.35000
+ 70.00n 1.35000 76.92n 1.35000
+ 77.00n 1.35000 83.92n 1.35000
+ 84.00n 1.50000 90.92n 1.50000
+ 91.00n 1.50000 97.92n 1.50000
+ 98.00n 1.50000 104.92n 1.50000
+ 105.00n 1.50000 111.92n 1.50000
+ 112.00n 1.50000 118.92n 1.50000
+ 119.00n 1.50000 125.92n 1.50000
+ 126.00n 1.50000 132.92n 1.50000
+ 133.00n 1.50000 139.92n 1.50000
+ 140.00n 1.50000 146.92n 1.50000
+ 147.00n 1.50000 153.92n 1.50000
+ 154.00n 1.50000 160.92n 1.50000
+ 161.00n 1.50000 167.92n 1.50000
+ 168.00n 1.65000 174.92n 1.65000
+ 175.00n 1.65000 181.92n 1.65000
+ 182.00n 1.65000 188.92n 1.65000
+ 189.00n 1.65000 195.92n 1.65000
+ 196.00n 1.65000 202.92n 1.65000
+ 203.00n 1.65000 209.92n 1.65000
+ 210.00n 1.65000 216.92n 1.65000
+ 217.00n 1.65000 223.92n 1.65000
+ 224.00n 1.65000 230.92n 1.65000
+ 231.00n 1.65000 237.92n 1.65000
+ 238.00n 1.65000 244.92n 1.65000
+ 245.00n 1.65000 251.92n 1.65000
+ 252.00n 1.65000)
Vdd11_2 vdd11_2 0 pwl(
+ 0.00n 0.99000 6.92n 0.99000
+ 7.00n 0.99000 13.92n 0.99000
+ 14.00n 0.99000 20.92n 0.99000
+ 21.00n 0.99000 27.92n 0.99000
+ 28.00n 0.99000 34.92n 0.99000
+ 35.00n 0.99000 41.92n 0.99000
+ 42.00n 0.99000 48.92n 0.99000
+ 49.00n 0.99000 55.92n 0.99000
+ 56.00n 0.99000 62.92n 0.99000
+ 63.00n 0.99000 69.92n 0.99000
+ 70.00n 0.99000 76.92n 0.99000
+ 77.00n 0.99000 83.92n 0.99000
+ 84.00n 1.10000 90.92n 1.10000
+ 91.00n 1.10000 97.92n 1.10000
+ 98.00n 1.10000 104.92n 1.10000
+ 105.00n 1.10000 111.92n 1.10000
+ 112.00n 1.10000 118.92n 1.10000
+ 119.00n 1.10000 125.92n 1.10000
+ 126.00n 1.10000 132.92n 1.10000
+ 133.00n 1.10000 139.92n 1.10000
+ 140.00n 1.10000 146.92n 1.10000
+ 147.00n 1.10000 153.92n 1.10000
+ 154.00n 1.10000 160.92n 1.10000
+ 161.00n 1.10000 167.92n 1.10000
+ 168.00n 1.21000 174.92n 1.21000
+ 175.00n 1.21000 181.92n 1.21000
+ 182.00n 1.21000 188.92n 1.21000
+ 189.00n 1.21000 195.92n 1.21000
+ 196.00n 1.21000 202.92n 1.21000
+ 203.00n 1.21000 209.92n 1.21000
+ 210.00n 1.21000 216.92n 1.21000
+ 217.00n 1.21000 223.92n 1.21000
+ 224.00n 1.21000 230.92n 1.21000
+ 231.00n 1.21000 237.92n 1.21000
+ 238.00n 1.21000 244.92n 1.21000
+ 245.00n 1.21000 251.92n 1.21000
+ 252.00n 1.21000)
Vss_2   vss_2   0 pwl(
+ 0.00n -0.05000 6.92n -0.05000
+ 7.00n -0.05000 13.92n -0.05000
+ 14.00n -0.05000 20.92n -0.05000
+ 21.00n -0.05000 27.92n -0.05000
+ 28.00n 0.00000 34.92n 0.00000
+ 35.00n 0.00000 41.92n 0.00000
+ 42.00n 0.00000 48.92n 0.00000
+ 49.00n 0.00000 55.92n 0.00000
+ 56.00n 0.05000 62.92n 0.05000
+ 63.00n 0.05000 69.92n 0.05000
+ 70.00n 0.05000 76.92n 0.05000
+ 77.00n 0.05000 83.92n 0.05000
+ 84.00n -0.05000 90.92n -0.05000
+ 91.00n -0.05000 97.92n -0.05000
+ 98.00n -0.05000 104.92n -0.05000
+ 105.00n -0.05000 111.92n -0.05000
+ 112.00n 0.00000 118.92n 0.00000
+ 119.00n 0.00000 125.92n 0.00000
+ 126.00n 0.00000 132.92n 0.00000
+ 133.00n 0.00000 139.92n 0.00000
+ 140.00n 0.05000 146.92n 0.05000
+ 147.00n 0.05000 153.92n 0.05000
+ 154.00n 0.05000 160.92n 0.05000
+ 161.00n 0.05000 167.92n 0.05000
+ 168.00n -0.05000 174.92n -0.05000
+ 175.00n -0.05000 181.92n -0.05000
+ 182.00n -0.05000 188.92n -0.05000
+ 189.00n -0.05000 195.92n -0.05000
+ 196.00n 0.00000 202.92n 0.00000
+ 203.00n 0.00000 209.92n 0.00000
+ 210.00n 0.00000 216.92n 0.00000
+ 217.00n 0.00000 223.92n 0.00000
+ 224.00n 0.05000 230.92n 0.05000
+ 231.00n 0.05000 237.92n 0.05000
+ 238.00n 0.05000 244.92n 0.05000
+ 245.00n 0.05000 251.92n 0.05000
+ 252.00n 0.05000)
Vgt08_2 gt08_k0_2 0 pwl(
+ 0.00n -0.45000 6.92n -0.45000
+ 7.00n -0.45000 13.92n -0.45000
+ 14.00n -0.45000 20.92n -0.45000
+ 21.00n -0.45000 27.92n -0.45000
+ 28.00n -0.40000 34.92n -0.40000
+ 35.00n -0.40000 41.92n -0.40000
+ 42.00n -0.40000 48.92n -0.40000
+ 49.00n -0.40000 55.92n -0.40000
+ 56.00n -0.35000 62.92n -0.35000
+ 63.00n -0.35000 69.92n -0.35000
+ 70.00n -0.35000 76.92n -0.35000
+ 77.00n -0.35000 83.92n -0.35000
+ 84.00n -0.45000 90.92n -0.45000
+ 91.00n -0.45000 97.92n -0.45000
+ 98.00n -0.45000 104.92n -0.45000
+ 105.00n -0.45000 111.92n -0.45000
+ 112.00n -0.40000 118.92n -0.40000
+ 119.00n -0.40000 125.92n -0.40000
+ 126.00n -0.40000 132.92n -0.40000
+ 133.00n -0.40000 139.92n -0.40000
+ 140.00n -0.35000 146.92n -0.35000
+ 147.00n -0.35000 153.92n -0.35000
+ 154.00n -0.35000 160.92n -0.35000
+ 161.00n -0.35000 167.92n -0.35000
+ 168.00n -0.45000 174.92n -0.45000
+ 175.00n -0.45000 181.92n -0.45000
+ 182.00n -0.45000 188.92n -0.45000
+ 189.00n -0.45000 195.92n -0.45000
+ 196.00n -0.40000 202.92n -0.40000
+ 203.00n -0.40000 209.92n -0.40000
+ 210.00n -0.40000 216.92n -0.40000
+ 217.00n -0.40000 223.92n -0.40000
+ 224.00n -0.35000 230.92n -0.35000
+ 231.00n -0.35000 237.92n -0.35000
+ 238.00n -0.35000 244.92n -0.35000
+ 245.00n -0.35000 251.92n -0.35000
+ 252.00n -0.35000)
Vgb08_2 gb08_k1_2 0 pwl(
+ 0.00n -0.75000 6.92n -0.75000
+ 7.00n -0.75000 13.92n -0.75000
+ 14.00n -0.75000 20.92n -0.75000
+ 21.00n -0.75000 27.92n -0.75000
+ 28.00n -0.70000 34.92n -0.70000
+ 35.00n -0.70000 41.92n -0.70000
+ 42.00n -0.70000 48.92n -0.70000
+ 49.00n -0.70000 55.92n -0.70000
+ 56.00n -0.65000 62.92n -0.65000
+ 63.00n -0.65000 69.92n -0.65000
+ 70.00n -0.65000 76.92n -0.65000
+ 77.00n -0.65000 83.92n -0.65000
+ 84.00n -0.75000 90.92n -0.75000
+ 91.00n -0.75000 97.92n -0.75000
+ 98.00n -0.75000 104.92n -0.75000
+ 105.00n -0.75000 111.92n -0.75000
+ 112.00n -0.70000 118.92n -0.70000
+ 119.00n -0.70000 125.92n -0.70000
+ 126.00n -0.70000 132.92n -0.70000
+ 133.00n -0.70000 139.92n -0.70000
+ 140.00n -0.65000 146.92n -0.65000
+ 147.00n -0.65000 153.92n -0.65000
+ 154.00n -0.65000 160.92n -0.65000
+ 161.00n -0.65000 167.92n -0.65000
+ 168.00n -0.75000 174.92n -0.75000
+ 175.00n -0.75000 181.92n -0.75000
+ 182.00n -0.75000 188.92n -0.75000
+ 189.00n -0.75000 195.92n -0.75000
+ 196.00n -0.70000 202.92n -0.70000
+ 203.00n -0.70000 209.92n -0.70000
+ 210.00n -0.70000 216.92n -0.70000
+ 217.00n -0.70000 223.92n -0.70000
+ 224.00n -0.65000 230.92n -0.65000
+ 231.00n -0.65000 237.92n -0.65000
+ 238.00n -0.65000 244.92n -0.65000
+ 245.00n -0.65000 251.92n -0.65000
+ 252.00n -0.65000)
Va08_2  a08_2   0 pwl(
+ 0.00n -0.05000 6.92n -0.05000
+ 7.00n -0.05000 13.92n -0.05000
+ 14.00n 0.72000 20.92n 0.72000
+ 21.00n 0.72000 27.92n 0.72000
+ 28.00n 0.00000 34.92n 0.00000
+ 35.00n 0.00000 41.92n 0.00000
+ 42.00n 0.72000 48.92n 0.72000
+ 49.00n 0.72000 55.92n 0.72000
+ 56.00n 0.05000 62.92n 0.05000
+ 63.00n 0.05000 69.92n 0.05000
+ 70.00n 0.72000 76.92n 0.72000
+ 77.00n 0.72000 83.92n 0.72000
+ 84.00n -0.05000 90.92n -0.05000
+ 91.00n -0.05000 97.92n -0.05000
+ 98.00n 0.80000 104.92n 0.80000
+ 105.00n 0.80000 111.92n 0.80000
+ 112.00n 0.00000 118.92n 0.00000
+ 119.00n 0.00000 125.92n 0.00000
+ 126.00n 0.80000 132.92n 0.80000
+ 133.00n 0.80000 139.92n 0.80000
+ 140.00n 0.05000 146.92n 0.05000
+ 147.00n 0.05000 153.92n 0.05000
+ 154.00n 0.80000 160.92n 0.80000
+ 161.00n 0.80000 167.92n 0.80000
+ 168.00n -0.05000 174.92n -0.05000
+ 175.00n -0.05000 181.92n -0.05000
+ 182.00n 0.88000 188.92n 0.88000
+ 189.00n 0.88000 195.92n 0.88000
+ 196.00n 0.00000 202.92n 0.00000
+ 203.00n 0.00000 209.92n 0.00000
+ 210.00n 0.88000 216.92n 0.88000
+ 217.00n 0.88000 223.92n 0.88000
+ 224.00n 0.05000 230.92n 0.05000
+ 231.00n 0.05000 237.92n 0.05000
+ 238.00n 0.88000 244.92n 0.88000
+ 245.00n 0.88000 251.92n 0.88000
+ 252.00n 0.88000)
Vb08_2  b08_2   0 pwl(
+ 0.00n -0.05000 6.92n -0.05000
+ 7.00n 0.72000 13.92n 0.72000
+ 14.00n -0.05000 20.92n -0.05000
+ 21.00n 0.72000 27.92n 0.72000
+ 28.00n 0.00000 34.92n 0.00000
+ 35.00n 0.72000 41.92n 0.72000
+ 42.00n 0.00000 48.92n 0.00000
+ 49.00n 0.72000 55.92n 0.72000
+ 56.00n 0.05000 62.92n 0.05000
+ 63.00n 0.72000 69.92n 0.72000
+ 70.00n 0.05000 76.92n 0.05000
+ 77.00n 0.72000 83.92n 0.72000
+ 84.00n -0.05000 90.92n -0.05000
+ 91.00n 0.80000 97.92n 0.80000
+ 98.00n -0.05000 104.92n -0.05000
+ 105.00n 0.80000 111.92n 0.80000
+ 112.00n 0.00000 118.92n 0.00000
+ 119.00n 0.80000 125.92n 0.80000
+ 126.00n 0.00000 132.92n 0.00000
+ 133.00n 0.80000 139.92n 0.80000
+ 140.00n 0.05000 146.92n 0.05000
+ 147.00n 0.80000 153.92n 0.80000
+ 154.00n 0.05000 160.92n 0.05000
+ 161.00n 0.80000 167.92n 0.80000
+ 168.00n -0.05000 174.92n -0.05000
+ 175.00n 0.88000 181.92n 0.88000
+ 182.00n -0.05000 188.92n -0.05000
+ 189.00n 0.88000 195.92n 0.88000
+ 196.00n 0.00000 202.92n 0.00000
+ 203.00n 0.88000 209.92n 0.88000
+ 210.00n 0.00000 216.92n 0.00000
+ 217.00n 0.88000 223.92n 0.88000
+ 224.00n 0.05000 230.92n 0.05000
+ 231.00n 0.88000 237.92n 0.88000
+ 238.00n 0.05000 244.92n 0.05000
+ 245.00n 0.88000 251.92n 0.88000
+ 252.00n 0.88000)
Va11_2  a11_2   0 pwl(
+ 0.00n -0.05000 6.92n -0.05000
+ 7.00n -0.05000 13.92n -0.05000
+ 14.00n 0.99000 20.92n 0.99000
+ 21.00n 0.99000 27.92n 0.99000
+ 28.00n 0.00000 34.92n 0.00000
+ 35.00n 0.00000 41.92n 0.00000
+ 42.00n 0.99000 48.92n 0.99000
+ 49.00n 0.99000 55.92n 0.99000
+ 56.00n 0.05000 62.92n 0.05000
+ 63.00n 0.05000 69.92n 0.05000
+ 70.00n 0.99000 76.92n 0.99000
+ 77.00n 0.99000 83.92n 0.99000
+ 84.00n -0.05000 90.92n -0.05000
+ 91.00n -0.05000 97.92n -0.05000
+ 98.00n 1.10000 104.92n 1.10000
+ 105.00n 1.10000 111.92n 1.10000
+ 112.00n 0.00000 118.92n 0.00000
+ 119.00n 0.00000 125.92n 0.00000
+ 126.00n 1.10000 132.92n 1.10000
+ 133.00n 1.10000 139.92n 1.10000
+ 140.00n 0.05000 146.92n 0.05000
+ 147.00n 0.05000 153.92n 0.05000
+ 154.00n 1.10000 160.92n 1.10000
+ 161.00n 1.10000 167.92n 1.10000
+ 168.00n -0.05000 174.92n -0.05000
+ 175.00n -0.05000 181.92n -0.05000
+ 182.00n 1.21000 188.92n 1.21000
+ 189.00n 1.21000 195.92n 1.21000
+ 196.00n 0.00000 202.92n 0.00000
+ 203.00n 0.00000 209.92n 0.00000
+ 210.00n 1.21000 216.92n 1.21000
+ 217.00n 1.21000 223.92n 1.21000
+ 224.00n 0.05000 230.92n 0.05000
+ 231.00n 0.05000 237.92n 0.05000
+ 238.00n 1.21000 244.92n 1.21000
+ 245.00n 1.21000 251.92n 1.21000
+ 252.00n 1.21000)
Van11_2 an11_2  0 pwl(
+ 0.00n 0.99000 6.92n 0.99000
+ 7.00n 0.99000 13.92n 0.99000
+ 14.00n -0.05000 20.92n -0.05000
+ 21.00n -0.05000 27.92n -0.05000
+ 28.00n 0.99000 34.92n 0.99000
+ 35.00n 0.99000 41.92n 0.99000
+ 42.00n 0.00000 48.92n 0.00000
+ 49.00n 0.00000 55.92n 0.00000
+ 56.00n 0.99000 62.92n 0.99000
+ 63.00n 0.99000 69.92n 0.99000
+ 70.00n 0.05000 76.92n 0.05000
+ 77.00n 0.05000 83.92n 0.05000
+ 84.00n 1.10000 90.92n 1.10000
+ 91.00n 1.10000 97.92n 1.10000
+ 98.00n -0.05000 104.92n -0.05000
+ 105.00n -0.05000 111.92n -0.05000
+ 112.00n 1.10000 118.92n 1.10000
+ 119.00n 1.10000 125.92n 1.10000
+ 126.00n 0.00000 132.92n 0.00000
+ 133.00n 0.00000 139.92n 0.00000
+ 140.00n 1.10000 146.92n 1.10000
+ 147.00n 1.10000 153.92n 1.10000
+ 154.00n 0.05000 160.92n 0.05000
+ 161.00n 0.05000 167.92n 0.05000
+ 168.00n 1.21000 174.92n 1.21000
+ 175.00n 1.21000 181.92n 1.21000
+ 182.00n -0.05000 188.92n -0.05000
+ 189.00n -0.05000 195.92n -0.05000
+ 196.00n 1.21000 202.92n 1.21000
+ 203.00n 1.21000 209.92n 1.21000
+ 210.00n 0.00000 216.92n 0.00000
+ 217.00n 0.00000 223.92n 0.00000
+ 224.00n 1.21000 230.92n 1.21000
+ 231.00n 1.21000 237.92n 1.21000
+ 238.00n 0.05000 244.92n 0.05000
+ 245.00n 0.05000 251.92n 0.05000
+ 252.00n 0.05000)
Vb11_2  b11_2   0 pwl(
+ 0.00n -0.05000 6.92n -0.05000
+ 7.00n 0.99000 13.92n 0.99000
+ 14.00n -0.05000 20.92n -0.05000
+ 21.00n 0.99000 27.92n 0.99000
+ 28.00n 0.00000 34.92n 0.00000
+ 35.00n 0.99000 41.92n 0.99000
+ 42.00n 0.00000 48.92n 0.00000
+ 49.00n 0.99000 55.92n 0.99000
+ 56.00n 0.05000 62.92n 0.05000
+ 63.00n 0.99000 69.92n 0.99000
+ 70.00n 0.05000 76.92n 0.05000
+ 77.00n 0.99000 83.92n 0.99000
+ 84.00n -0.05000 90.92n -0.05000
+ 91.00n 1.10000 97.92n 1.10000
+ 98.00n -0.05000 104.92n -0.05000
+ 105.00n 1.10000 111.92n 1.10000
+ 112.00n 0.00000 118.92n 0.00000
+ 119.00n 1.10000 125.92n 1.10000
+ 126.00n 0.00000 132.92n 0.00000
+ 133.00n 1.10000 139.92n 1.10000
+ 140.00n 0.05000 146.92n 0.05000
+ 147.00n 1.10000 153.92n 1.10000
+ 154.00n 0.05000 160.92n 0.05000
+ 161.00n 1.10000 167.92n 1.10000
+ 168.00n -0.05000 174.92n -0.05000
+ 175.00n 1.21000 181.92n 1.21000
+ 182.00n -0.05000 188.92n -0.05000
+ 189.00n 1.21000 195.92n 1.21000
+ 196.00n 0.00000 202.92n 0.00000
+ 203.00n 1.21000 209.92n 1.21000
+ 210.00n 0.00000 216.92n 0.00000
+ 217.00n 1.21000 223.92n 1.21000
+ 224.00n 0.05000 230.92n 0.05000
+ 231.00n 1.21000 237.92n 1.21000
+ 238.00n 0.05000 244.92n 0.05000
+ 245.00n 1.21000 251.92n 1.21000
+ 252.00n 1.21000)
Vbn11_2 bn11_2  0 pwl(
+ 0.00n 0.99000 6.92n 0.99000
+ 7.00n -0.05000 13.92n -0.05000
+ 14.00n 0.99000 20.92n 0.99000
+ 21.00n -0.05000 27.92n -0.05000
+ 28.00n 0.99000 34.92n 0.99000
+ 35.00n 0.00000 41.92n 0.00000
+ 42.00n 0.99000 48.92n 0.99000
+ 49.00n 0.00000 55.92n 0.00000
+ 56.00n 0.99000 62.92n 0.99000
+ 63.00n 0.05000 69.92n 0.05000
+ 70.00n 0.99000 76.92n 0.99000
+ 77.00n 0.05000 83.92n 0.05000
+ 84.00n 1.10000 90.92n 1.10000
+ 91.00n -0.05000 97.92n -0.05000
+ 98.00n 1.10000 104.92n 1.10000
+ 105.00n -0.05000 111.92n -0.05000
+ 112.00n 1.10000 118.92n 1.10000
+ 119.00n 0.00000 125.92n 0.00000
+ 126.00n 1.10000 132.92n 1.10000
+ 133.00n 0.00000 139.92n 0.00000
+ 140.00n 1.10000 146.92n 1.10000
+ 147.00n 0.05000 153.92n 0.05000
+ 154.00n 1.10000 160.92n 1.10000
+ 161.00n 0.05000 167.92n 0.05000
+ 168.00n 1.21000 174.92n 1.21000
+ 175.00n -0.05000 181.92n -0.05000
+ 182.00n 1.21000 188.92n 1.21000
+ 189.00n -0.05000 195.92n -0.05000
+ 196.00n 1.21000 202.92n 1.21000
+ 203.00n 0.00000 209.92n 0.00000
+ 210.00n 1.21000 216.92n 1.21000
+ 217.00n 0.00000 223.92n 0.00000
+ 224.00n 1.21000 230.92n 1.21000
+ 231.00n 0.05000 237.92n 0.05000
+ 238.00n 1.21000 244.92n 1.21000
+ 245.00n 0.05000 251.92n 0.05000
+ 252.00n 0.05000)

B_rt08_2 rtop08_2 0 V = (mode_k < 0.5) ? v(vdd08_2) : v(vss_2)
B_gt08_2 gtop08_2 0 V = (mode_k < 0.5) ? v(gt08_k0_2) : v(vdd08_2)
B_rb08_2 rbot08_2 0 V = (mode_k < 0.5) ? v(vss_2)   : v(vdd08_2)
B_gb08_2 gbot08_2 0 V = (mode_k < 0.5) ? v(vdd08_2) : v(gb08_k1_2)
B_rt15_2 rtop15_2 0 V = (mode_k < 0.5) ? v(vdd15_2) : v(vss_2)
B_gt15_2 gtop15_2 0 V = (mode_k < 0.5) ? v(vss_2)   : 0.8
B_rb15_2 rbot15_2 0 V = (mode_k < 0.5) ? v(vss_2)   : v(vdd15_2)
B_gb15_2 gbot15_2 0 V = (mode_k < 0.5) ? 0.8        : v(vss_2)
B_k_2    k_2      0 V = (mode_k < 0.5) ? v(vss_2)   : v(vdd11_2)
B_kn_2   kn_2     0 V = (mode_k < 0.5) ? v(vdd11_2) : v(vss_2)

Vgn gn 0 0.8

* 1) (NAND, NOR)
X_NN a08_2 b08_2 out_nn rtop08_2 gtop08_2 rbot08_2 gbot08_2 POLY_NAND_NOR
Cout_nn out_nn 0 0.3f

* 2) (XOR, XNOR)
X_XX a11_2 an11_2 b11_2 bn11_2 out_xx rtop15_2 gtop15_2 rbot15_2 gbot15_2 POLY_XOR
Cout_xx out_xx 0 0.3f

* 3) (AND, OR)
X_AO_PRE a08_2 b08_2 n_ao rtop08_2 gtop08_2 rbot08_2 gbot08_2 POLY_NAND_NOR
X_AO_INV n_ao out_ao vdd08_2 vss_2 BP_INV08
Cn_ao   n_ao   0 0.1f
Cout_ao out_ao 0 0.2f

* 4) (NAND, XNOR)
XNX1 out_nx an11_2  rtop15_2 b11_2   gtop15_2 ARI W=1.0
XNX2 out_nx a11_2   rtop15_2 bn11_2  gtop15_2 ARI W=1.0
XNX3 out_nx a11_2   vdd15_2  b11_2   vss_2    ARI W=1.0
XNX4 out_nx a11_2   rbot15_2 b11_2   gbot15_2 ARI W=1.0
XNX5 out_nx an11_2  n11p_nx  bn11_2  vss_2    ARI W=2.0
XNX6 n11p_nx kn_2   vdd15_2  kn_2    vss_2    ARI W=2.0
Cn11p_nx n11p_nx 0 0.05f
Cout_nx  out_nx  0 0.3f

* 5) (NOR, XOR)
XRX1 out_rx an11_2  rbot15_2 b11_2   gbot15_2 ARI W=1.0
XRX2 out_rx a11_2   rbot15_2 bn11_2  gbot15_2 ARI W=1.0
XRX3 out_rx a11_2   vss_2    b11_2   gn       ARI W=1.0
XRX4 out_rx a11_2   rtop15_2 b11_2   gtop15_2 ARI W=1.0
XRX5 out_rx an11_2  n00n_rx  bn11_2  gn       ARI W=2.0
XRX6 n00n_rx k_2    vss_2    k_2     gn       ARI W=2.0
Cn00n_rx n00n_rx 0 0.05f
Cout_rx  out_rx  0 0.3f

* --- Alimentacoes e Entradas Bloco 3-Entradas (step = 3.5 ns/vetor, total = 252 ns) ---
Vdd08_3 vdd08_3 0 pwl(
+ 0.00n 0.72000 3.42n 0.72000
+ 3.50n 0.72000 6.92n 0.72000
+ 7.00n 0.72000 10.42n 0.72000
+ 10.50n 0.72000 13.92n 0.72000
+ 14.00n 0.72000 17.42n 0.72000
+ 17.50n 0.72000 20.92n 0.72000
+ 21.00n 0.72000 24.42n 0.72000
+ 24.50n 0.72000 27.92n 0.72000
+ 28.00n 0.72000 31.42n 0.72000
+ 31.50n 0.72000 34.92n 0.72000
+ 35.00n 0.72000 38.42n 0.72000
+ 38.50n 0.72000 41.92n 0.72000
+ 42.00n 0.72000 45.42n 0.72000
+ 45.50n 0.72000 48.92n 0.72000
+ 49.00n 0.72000 52.42n 0.72000
+ 52.50n 0.72000 55.92n 0.72000
+ 56.00n 0.72000 59.42n 0.72000
+ 59.50n 0.72000 62.92n 0.72000
+ 63.00n 0.72000 66.42n 0.72000
+ 66.50n 0.72000 69.92n 0.72000
+ 70.00n 0.72000 73.42n 0.72000
+ 73.50n 0.72000 76.92n 0.72000
+ 77.00n 0.72000 80.42n 0.72000
+ 80.50n 0.72000 83.92n 0.72000
+ 84.00n 0.80000 87.42n 0.80000
+ 87.50n 0.80000 90.92n 0.80000
+ 91.00n 0.80000 94.42n 0.80000
+ 94.50n 0.80000 97.92n 0.80000
+ 98.00n 0.80000 101.42n 0.80000
+ 101.50n 0.80000 104.92n 0.80000
+ 105.00n 0.80000 108.42n 0.80000
+ 108.50n 0.80000 111.92n 0.80000
+ 112.00n 0.80000 115.42n 0.80000
+ 115.50n 0.80000 118.92n 0.80000
+ 119.00n 0.80000 122.42n 0.80000
+ 122.50n 0.80000 125.92n 0.80000
+ 126.00n 0.80000 129.42n 0.80000
+ 129.50n 0.80000 132.92n 0.80000
+ 133.00n 0.80000 136.42n 0.80000
+ 136.50n 0.80000 139.92n 0.80000
+ 140.00n 0.80000 143.42n 0.80000
+ 143.50n 0.80000 146.92n 0.80000
+ 147.00n 0.80000 150.42n 0.80000
+ 150.50n 0.80000 153.92n 0.80000
+ 154.00n 0.80000 157.42n 0.80000
+ 157.50n 0.80000 160.92n 0.80000
+ 161.00n 0.80000 164.42n 0.80000
+ 164.50n 0.80000 167.92n 0.80000
+ 168.00n 0.88000 171.42n 0.88000
+ 171.50n 0.88000 174.92n 0.88000
+ 175.00n 0.88000 178.42n 0.88000
+ 178.50n 0.88000 181.92n 0.88000
+ 182.00n 0.88000 185.42n 0.88000
+ 185.50n 0.88000 188.92n 0.88000
+ 189.00n 0.88000 192.42n 0.88000
+ 192.50n 0.88000 195.92n 0.88000
+ 196.00n 0.88000 199.42n 0.88000
+ 199.50n 0.88000 202.92n 0.88000
+ 203.00n 0.88000 206.42n 0.88000
+ 206.50n 0.88000 209.92n 0.88000
+ 210.00n 0.88000 213.42n 0.88000
+ 213.50n 0.88000 216.92n 0.88000
+ 217.00n 0.88000 220.42n 0.88000
+ 220.50n 0.88000 223.92n 0.88000
+ 224.00n 0.88000 227.42n 0.88000
+ 227.50n 0.88000 230.92n 0.88000
+ 231.00n 0.88000 234.42n 0.88000
+ 234.50n 0.88000 237.92n 0.88000
+ 238.00n 0.88000 241.42n 0.88000
+ 241.50n 0.88000 244.92n 0.88000
+ 245.00n 0.88000 248.42n 0.88000
+ 248.50n 0.88000 251.92n 0.88000
+ 252.00n 0.88000)
Vdd15_3 vdd15_3 0 pwl(
+ 0.00n 1.35000 3.42n 1.35000
+ 3.50n 1.35000 6.92n 1.35000
+ 7.00n 1.35000 10.42n 1.35000
+ 10.50n 1.35000 13.92n 1.35000
+ 14.00n 1.35000 17.42n 1.35000
+ 17.50n 1.35000 20.92n 1.35000
+ 21.00n 1.35000 24.42n 1.35000
+ 24.50n 1.35000 27.92n 1.35000
+ 28.00n 1.35000 31.42n 1.35000
+ 31.50n 1.35000 34.92n 1.35000
+ 35.00n 1.35000 38.42n 1.35000
+ 38.50n 1.35000 41.92n 1.35000
+ 42.00n 1.35000 45.42n 1.35000
+ 45.50n 1.35000 48.92n 1.35000
+ 49.00n 1.35000 52.42n 1.35000
+ 52.50n 1.35000 55.92n 1.35000
+ 56.00n 1.35000 59.42n 1.35000
+ 59.50n 1.35000 62.92n 1.35000
+ 63.00n 1.35000 66.42n 1.35000
+ 66.50n 1.35000 69.92n 1.35000
+ 70.00n 1.35000 73.42n 1.35000
+ 73.50n 1.35000 76.92n 1.35000
+ 77.00n 1.35000 80.42n 1.35000
+ 80.50n 1.35000 83.92n 1.35000
+ 84.00n 1.50000 87.42n 1.50000
+ 87.50n 1.50000 90.92n 1.50000
+ 91.00n 1.50000 94.42n 1.50000
+ 94.50n 1.50000 97.92n 1.50000
+ 98.00n 1.50000 101.42n 1.50000
+ 101.50n 1.50000 104.92n 1.50000
+ 105.00n 1.50000 108.42n 1.50000
+ 108.50n 1.50000 111.92n 1.50000
+ 112.00n 1.50000 115.42n 1.50000
+ 115.50n 1.50000 118.92n 1.50000
+ 119.00n 1.50000 122.42n 1.50000
+ 122.50n 1.50000 125.92n 1.50000
+ 126.00n 1.50000 129.42n 1.50000
+ 129.50n 1.50000 132.92n 1.50000
+ 133.00n 1.50000 136.42n 1.50000
+ 136.50n 1.50000 139.92n 1.50000
+ 140.00n 1.50000 143.42n 1.50000
+ 143.50n 1.50000 146.92n 1.50000
+ 147.00n 1.50000 150.42n 1.50000
+ 150.50n 1.50000 153.92n 1.50000
+ 154.00n 1.50000 157.42n 1.50000
+ 157.50n 1.50000 160.92n 1.50000
+ 161.00n 1.50000 164.42n 1.50000
+ 164.50n 1.50000 167.92n 1.50000
+ 168.00n 1.65000 171.42n 1.65000
+ 171.50n 1.65000 174.92n 1.65000
+ 175.00n 1.65000 178.42n 1.65000
+ 178.50n 1.65000 181.92n 1.65000
+ 182.00n 1.65000 185.42n 1.65000
+ 185.50n 1.65000 188.92n 1.65000
+ 189.00n 1.65000 192.42n 1.65000
+ 192.50n 1.65000 195.92n 1.65000
+ 196.00n 1.65000 199.42n 1.65000
+ 199.50n 1.65000 202.92n 1.65000
+ 203.00n 1.65000 206.42n 1.65000
+ 206.50n 1.65000 209.92n 1.65000
+ 210.00n 1.65000 213.42n 1.65000
+ 213.50n 1.65000 216.92n 1.65000
+ 217.00n 1.65000 220.42n 1.65000
+ 220.50n 1.65000 223.92n 1.65000
+ 224.00n 1.65000 227.42n 1.65000
+ 227.50n 1.65000 230.92n 1.65000
+ 231.00n 1.65000 234.42n 1.65000
+ 234.50n 1.65000 237.92n 1.65000
+ 238.00n 1.65000 241.42n 1.65000
+ 241.50n 1.65000 244.92n 1.65000
+ 245.00n 1.65000 248.42n 1.65000
+ 248.50n 1.65000 251.92n 1.65000
+ 252.00n 1.65000)
Vdd11_3 vdd11_3 0 pwl(
+ 0.00n 0.99000 3.42n 0.99000
+ 3.50n 0.99000 6.92n 0.99000
+ 7.00n 0.99000 10.42n 0.99000
+ 10.50n 0.99000 13.92n 0.99000
+ 14.00n 0.99000 17.42n 0.99000
+ 17.50n 0.99000 20.92n 0.99000
+ 21.00n 0.99000 24.42n 0.99000
+ 24.50n 0.99000 27.92n 0.99000
+ 28.00n 0.99000 31.42n 0.99000
+ 31.50n 0.99000 34.92n 0.99000
+ 35.00n 0.99000 38.42n 0.99000
+ 38.50n 0.99000 41.92n 0.99000
+ 42.00n 0.99000 45.42n 0.99000
+ 45.50n 0.99000 48.92n 0.99000
+ 49.00n 0.99000 52.42n 0.99000
+ 52.50n 0.99000 55.92n 0.99000
+ 56.00n 0.99000 59.42n 0.99000
+ 59.50n 0.99000 62.92n 0.99000
+ 63.00n 0.99000 66.42n 0.99000
+ 66.50n 0.99000 69.92n 0.99000
+ 70.00n 0.99000 73.42n 0.99000
+ 73.50n 0.99000 76.92n 0.99000
+ 77.00n 0.99000 80.42n 0.99000
+ 80.50n 0.99000 83.92n 0.99000
+ 84.00n 1.10000 87.42n 1.10000
+ 87.50n 1.10000 90.92n 1.10000
+ 91.00n 1.10000 94.42n 1.10000
+ 94.50n 1.10000 97.92n 1.10000
+ 98.00n 1.10000 101.42n 1.10000
+ 101.50n 1.10000 104.92n 1.10000
+ 105.00n 1.10000 108.42n 1.10000
+ 108.50n 1.10000 111.92n 1.10000
+ 112.00n 1.10000 115.42n 1.10000
+ 115.50n 1.10000 118.92n 1.10000
+ 119.00n 1.10000 122.42n 1.10000
+ 122.50n 1.10000 125.92n 1.10000
+ 126.00n 1.10000 129.42n 1.10000
+ 129.50n 1.10000 132.92n 1.10000
+ 133.00n 1.10000 136.42n 1.10000
+ 136.50n 1.10000 139.92n 1.10000
+ 140.00n 1.10000 143.42n 1.10000
+ 143.50n 1.10000 146.92n 1.10000
+ 147.00n 1.10000 150.42n 1.10000
+ 150.50n 1.10000 153.92n 1.10000
+ 154.00n 1.10000 157.42n 1.10000
+ 157.50n 1.10000 160.92n 1.10000
+ 161.00n 1.10000 164.42n 1.10000
+ 164.50n 1.10000 167.92n 1.10000
+ 168.00n 1.21000 171.42n 1.21000
+ 171.50n 1.21000 174.92n 1.21000
+ 175.00n 1.21000 178.42n 1.21000
+ 178.50n 1.21000 181.92n 1.21000
+ 182.00n 1.21000 185.42n 1.21000
+ 185.50n 1.21000 188.92n 1.21000
+ 189.00n 1.21000 192.42n 1.21000
+ 192.50n 1.21000 195.92n 1.21000
+ 196.00n 1.21000 199.42n 1.21000
+ 199.50n 1.21000 202.92n 1.21000
+ 203.00n 1.21000 206.42n 1.21000
+ 206.50n 1.21000 209.92n 1.21000
+ 210.00n 1.21000 213.42n 1.21000
+ 213.50n 1.21000 216.92n 1.21000
+ 217.00n 1.21000 220.42n 1.21000
+ 220.50n 1.21000 223.92n 1.21000
+ 224.00n 1.21000 227.42n 1.21000
+ 227.50n 1.21000 230.92n 1.21000
+ 231.00n 1.21000 234.42n 1.21000
+ 234.50n 1.21000 237.92n 1.21000
+ 238.00n 1.21000 241.42n 1.21000
+ 241.50n 1.21000 244.92n 1.21000
+ 245.00n 1.21000 248.42n 1.21000
+ 248.50n 1.21000 251.92n 1.21000
+ 252.00n 1.21000)
Vss_3   vss_3   0 pwl(
+ 0.00n -0.05000 3.42n -0.05000
+ 3.50n -0.05000 6.92n -0.05000
+ 7.00n -0.05000 10.42n -0.05000
+ 10.50n -0.05000 13.92n -0.05000
+ 14.00n -0.05000 17.42n -0.05000
+ 17.50n -0.05000 20.92n -0.05000
+ 21.00n -0.05000 24.42n -0.05000
+ 24.50n -0.05000 27.92n -0.05000
+ 28.00n 0.00000 31.42n 0.00000
+ 31.50n 0.00000 34.92n 0.00000
+ 35.00n 0.00000 38.42n 0.00000
+ 38.50n 0.00000 41.92n 0.00000
+ 42.00n 0.00000 45.42n 0.00000
+ 45.50n 0.00000 48.92n 0.00000
+ 49.00n 0.00000 52.42n 0.00000
+ 52.50n 0.00000 55.92n 0.00000
+ 56.00n 0.05000 59.42n 0.05000
+ 59.50n 0.05000 62.92n 0.05000
+ 63.00n 0.05000 66.42n 0.05000
+ 66.50n 0.05000 69.92n 0.05000
+ 70.00n 0.05000 73.42n 0.05000
+ 73.50n 0.05000 76.92n 0.05000
+ 77.00n 0.05000 80.42n 0.05000
+ 80.50n 0.05000 83.92n 0.05000
+ 84.00n -0.05000 87.42n -0.05000
+ 87.50n -0.05000 90.92n -0.05000
+ 91.00n -0.05000 94.42n -0.05000
+ 94.50n -0.05000 97.92n -0.05000
+ 98.00n -0.05000 101.42n -0.05000
+ 101.50n -0.05000 104.92n -0.05000
+ 105.00n -0.05000 108.42n -0.05000
+ 108.50n -0.05000 111.92n -0.05000
+ 112.00n 0.00000 115.42n 0.00000
+ 115.50n 0.00000 118.92n 0.00000
+ 119.00n 0.00000 122.42n 0.00000
+ 122.50n 0.00000 125.92n 0.00000
+ 126.00n 0.00000 129.42n 0.00000
+ 129.50n 0.00000 132.92n 0.00000
+ 133.00n 0.00000 136.42n 0.00000
+ 136.50n 0.00000 139.92n 0.00000
+ 140.00n 0.05000 143.42n 0.05000
+ 143.50n 0.05000 146.92n 0.05000
+ 147.00n 0.05000 150.42n 0.05000
+ 150.50n 0.05000 153.92n 0.05000
+ 154.00n 0.05000 157.42n 0.05000
+ 157.50n 0.05000 160.92n 0.05000
+ 161.00n 0.05000 164.42n 0.05000
+ 164.50n 0.05000 167.92n 0.05000
+ 168.00n -0.05000 171.42n -0.05000
+ 171.50n -0.05000 174.92n -0.05000
+ 175.00n -0.05000 178.42n -0.05000
+ 178.50n -0.05000 181.92n -0.05000
+ 182.00n -0.05000 185.42n -0.05000
+ 185.50n -0.05000 188.92n -0.05000
+ 189.00n -0.05000 192.42n -0.05000
+ 192.50n -0.05000 195.92n -0.05000
+ 196.00n 0.00000 199.42n 0.00000
+ 199.50n 0.00000 202.92n 0.00000
+ 203.00n 0.00000 206.42n 0.00000
+ 206.50n 0.00000 209.92n 0.00000
+ 210.00n 0.00000 213.42n 0.00000
+ 213.50n 0.00000 216.92n 0.00000
+ 217.00n 0.00000 220.42n 0.00000
+ 220.50n 0.00000 223.92n 0.00000
+ 224.00n 0.05000 227.42n 0.05000
+ 227.50n 0.05000 230.92n 0.05000
+ 231.00n 0.05000 234.42n 0.05000
+ 234.50n 0.05000 237.92n 0.05000
+ 238.00n 0.05000 241.42n 0.05000
+ 241.50n 0.05000 244.92n 0.05000
+ 245.00n 0.05000 248.42n 0.05000
+ 248.50n 0.05000 251.92n 0.05000
+ 252.00n 0.05000)
Vgta_3  gta_k0_3  0 pwl(
+ 0.00n -0.55000 3.42n -0.55000
+ 3.50n -0.55000 6.92n -0.55000
+ 7.00n -0.55000 10.42n -0.55000
+ 10.50n -0.55000 13.92n -0.55000
+ 14.00n -0.55000 17.42n -0.55000
+ 17.50n -0.55000 20.92n -0.55000
+ 21.00n -0.55000 24.42n -0.55000
+ 24.50n -0.55000 27.92n -0.55000
+ 28.00n -0.50000 31.42n -0.50000
+ 31.50n -0.50000 34.92n -0.50000
+ 35.00n -0.50000 38.42n -0.50000
+ 38.50n -0.50000 41.92n -0.50000
+ 42.00n -0.50000 45.42n -0.50000
+ 45.50n -0.50000 48.92n -0.50000
+ 49.00n -0.50000 52.42n -0.50000
+ 52.50n -0.50000 55.92n -0.50000
+ 56.00n -0.45000 59.42n -0.45000
+ 59.50n -0.45000 62.92n -0.45000
+ 63.00n -0.45000 66.42n -0.45000
+ 66.50n -0.45000 69.92n -0.45000
+ 70.00n -0.45000 73.42n -0.45000
+ 73.50n -0.45000 76.92n -0.45000
+ 77.00n -0.45000 80.42n -0.45000
+ 80.50n -0.45000 83.92n -0.45000
+ 84.00n -0.55000 87.42n -0.55000
+ 87.50n -0.55000 90.92n -0.55000
+ 91.00n -0.55000 94.42n -0.55000
+ 94.50n -0.55000 97.92n -0.55000
+ 98.00n -0.55000 101.42n -0.55000
+ 101.50n -0.55000 104.92n -0.55000
+ 105.00n -0.55000 108.42n -0.55000
+ 108.50n -0.55000 111.92n -0.55000
+ 112.00n -0.50000 115.42n -0.50000
+ 115.50n -0.50000 118.92n -0.50000
+ 119.00n -0.50000 122.42n -0.50000
+ 122.50n -0.50000 125.92n -0.50000
+ 126.00n -0.50000 129.42n -0.50000
+ 129.50n -0.50000 132.92n -0.50000
+ 133.00n -0.50000 136.42n -0.50000
+ 136.50n -0.50000 139.92n -0.50000
+ 140.00n -0.45000 143.42n -0.45000
+ 143.50n -0.45000 146.92n -0.45000
+ 147.00n -0.45000 150.42n -0.45000
+ 150.50n -0.45000 153.92n -0.45000
+ 154.00n -0.45000 157.42n -0.45000
+ 157.50n -0.45000 160.92n -0.45000
+ 161.00n -0.45000 164.42n -0.45000
+ 164.50n -0.45000 167.92n -0.45000
+ 168.00n -0.55000 171.42n -0.55000
+ 171.50n -0.55000 174.92n -0.55000
+ 175.00n -0.55000 178.42n -0.55000
+ 178.50n -0.55000 181.92n -0.55000
+ 182.00n -0.55000 185.42n -0.55000
+ 185.50n -0.55000 188.92n -0.55000
+ 189.00n -0.55000 192.42n -0.55000
+ 192.50n -0.55000 195.92n -0.55000
+ 196.00n -0.50000 199.42n -0.50000
+ 199.50n -0.50000 202.92n -0.50000
+ 203.00n -0.50000 206.42n -0.50000
+ 206.50n -0.50000 209.92n -0.50000
+ 210.00n -0.50000 213.42n -0.50000
+ 213.50n -0.50000 216.92n -0.50000
+ 217.00n -0.50000 220.42n -0.50000
+ 220.50n -0.50000 223.92n -0.50000
+ 224.00n -0.45000 227.42n -0.45000
+ 227.50n -0.45000 230.92n -0.45000
+ 231.00n -0.45000 234.42n -0.45000
+ 234.50n -0.45000 237.92n -0.45000
+ 238.00n -0.45000 241.42n -0.45000
+ 241.50n -0.45000 244.92n -0.45000
+ 245.00n -0.45000 248.42n -0.45000
+ 248.50n -0.45000 251.92n -0.45000
+ 252.00n -0.45000)
Vgb08_3 gb08_k1_3 0 pwl(
+ 0.00n -0.75000 3.42n -0.75000
+ 3.50n -0.75000 6.92n -0.75000
+ 7.00n -0.75000 10.42n -0.75000
+ 10.50n -0.75000 13.92n -0.75000
+ 14.00n -0.75000 17.42n -0.75000
+ 17.50n -0.75000 20.92n -0.75000
+ 21.00n -0.75000 24.42n -0.75000
+ 24.50n -0.75000 27.92n -0.75000
+ 28.00n -0.70000 31.42n -0.70000
+ 31.50n -0.70000 34.92n -0.70000
+ 35.00n -0.70000 38.42n -0.70000
+ 38.50n -0.70000 41.92n -0.70000
+ 42.00n -0.70000 45.42n -0.70000
+ 45.50n -0.70000 48.92n -0.70000
+ 49.00n -0.70000 52.42n -0.70000
+ 52.50n -0.70000 55.92n -0.70000
+ 56.00n -0.65000 59.42n -0.65000
+ 59.50n -0.65000 62.92n -0.65000
+ 63.00n -0.65000 66.42n -0.65000
+ 66.50n -0.65000 69.92n -0.65000
+ 70.00n -0.65000 73.42n -0.65000
+ 73.50n -0.65000 76.92n -0.65000
+ 77.00n -0.65000 80.42n -0.65000
+ 80.50n -0.65000 83.92n -0.65000
+ 84.00n -0.75000 87.42n -0.75000
+ 87.50n -0.75000 90.92n -0.75000
+ 91.00n -0.75000 94.42n -0.75000
+ 94.50n -0.75000 97.92n -0.75000
+ 98.00n -0.75000 101.42n -0.75000
+ 101.50n -0.75000 104.92n -0.75000
+ 105.00n -0.75000 108.42n -0.75000
+ 108.50n -0.75000 111.92n -0.75000
+ 112.00n -0.70000 115.42n -0.70000
+ 115.50n -0.70000 118.92n -0.70000
+ 119.00n -0.70000 122.42n -0.70000
+ 122.50n -0.70000 125.92n -0.70000
+ 126.00n -0.70000 129.42n -0.70000
+ 129.50n -0.70000 132.92n -0.70000
+ 133.00n -0.70000 136.42n -0.70000
+ 136.50n -0.70000 139.92n -0.70000
+ 140.00n -0.65000 143.42n -0.65000
+ 143.50n -0.65000 146.92n -0.65000
+ 147.00n -0.65000 150.42n -0.65000
+ 150.50n -0.65000 153.92n -0.65000
+ 154.00n -0.65000 157.42n -0.65000
+ 157.50n -0.65000 160.92n -0.65000
+ 161.00n -0.65000 164.42n -0.65000
+ 164.50n -0.65000 167.92n -0.65000
+ 168.00n -0.75000 171.42n -0.75000
+ 171.50n -0.75000 174.92n -0.75000
+ 175.00n -0.75000 178.42n -0.75000
+ 178.50n -0.75000 181.92n -0.75000
+ 182.00n -0.75000 185.42n -0.75000
+ 185.50n -0.75000 188.92n -0.75000
+ 189.00n -0.75000 192.42n -0.75000
+ 192.50n -0.75000 195.92n -0.75000
+ 196.00n -0.70000 199.42n -0.70000
+ 199.50n -0.70000 202.92n -0.70000
+ 203.00n -0.70000 206.42n -0.70000
+ 206.50n -0.70000 209.92n -0.70000
+ 210.00n -0.70000 213.42n -0.70000
+ 213.50n -0.70000 216.92n -0.70000
+ 217.00n -0.70000 220.42n -0.70000
+ 220.50n -0.70000 223.92n -0.70000
+ 224.00n -0.65000 227.42n -0.65000
+ 227.50n -0.65000 230.92n -0.65000
+ 231.00n -0.65000 234.42n -0.65000
+ 234.50n -0.65000 237.92n -0.65000
+ 238.00n -0.65000 241.42n -0.65000
+ 241.50n -0.65000 244.92n -0.65000
+ 245.00n -0.65000 248.42n -0.65000
+ 248.50n -0.65000 251.92n -0.65000
+ 252.00n -0.65000)
Va08_3  a08_3   0 pwl(
+ 0.00n -0.05000 3.42n -0.05000
+ 3.50n -0.05000 6.92n -0.05000
+ 7.00n -0.05000 10.42n -0.05000
+ 10.50n -0.05000 13.92n -0.05000
+ 14.00n 0.72000 17.42n 0.72000
+ 17.50n 0.72000 20.92n 0.72000
+ 21.00n 0.72000 24.42n 0.72000
+ 24.50n 0.72000 27.92n 0.72000
+ 28.00n 0.00000 31.42n 0.00000
+ 31.50n 0.00000 34.92n 0.00000
+ 35.00n 0.00000 38.42n 0.00000
+ 38.50n 0.00000 41.92n 0.00000
+ 42.00n 0.72000 45.42n 0.72000
+ 45.50n 0.72000 48.92n 0.72000
+ 49.00n 0.72000 52.42n 0.72000
+ 52.50n 0.72000 55.92n 0.72000
+ 56.00n 0.05000 59.42n 0.05000
+ 59.50n 0.05000 62.92n 0.05000
+ 63.00n 0.05000 66.42n 0.05000
+ 66.50n 0.05000 69.92n 0.05000
+ 70.00n 0.72000 73.42n 0.72000
+ 73.50n 0.72000 76.92n 0.72000
+ 77.00n 0.72000 80.42n 0.72000
+ 80.50n 0.72000 83.92n 0.72000
+ 84.00n -0.05000 87.42n -0.05000
+ 87.50n -0.05000 90.92n -0.05000
+ 91.00n -0.05000 94.42n -0.05000
+ 94.50n -0.05000 97.92n -0.05000
+ 98.00n 0.80000 101.42n 0.80000
+ 101.50n 0.80000 104.92n 0.80000
+ 105.00n 0.80000 108.42n 0.80000
+ 108.50n 0.80000 111.92n 0.80000
+ 112.00n 0.00000 115.42n 0.00000
+ 115.50n 0.00000 118.92n 0.00000
+ 119.00n 0.00000 122.42n 0.00000
+ 122.50n 0.00000 125.92n 0.00000
+ 126.00n 0.80000 129.42n 0.80000
+ 129.50n 0.80000 132.92n 0.80000
+ 133.00n 0.80000 136.42n 0.80000
+ 136.50n 0.80000 139.92n 0.80000
+ 140.00n 0.05000 143.42n 0.05000
+ 143.50n 0.05000 146.92n 0.05000
+ 147.00n 0.05000 150.42n 0.05000
+ 150.50n 0.05000 153.92n 0.05000
+ 154.00n 0.80000 157.42n 0.80000
+ 157.50n 0.80000 160.92n 0.80000
+ 161.00n 0.80000 164.42n 0.80000
+ 164.50n 0.80000 167.92n 0.80000
+ 168.00n -0.05000 171.42n -0.05000
+ 171.50n -0.05000 174.92n -0.05000
+ 175.00n -0.05000 178.42n -0.05000
+ 178.50n -0.05000 181.92n -0.05000
+ 182.00n 0.88000 185.42n 0.88000
+ 185.50n 0.88000 188.92n 0.88000
+ 189.00n 0.88000 192.42n 0.88000
+ 192.50n 0.88000 195.92n 0.88000
+ 196.00n 0.00000 199.42n 0.00000
+ 199.50n 0.00000 202.92n 0.00000
+ 203.00n 0.00000 206.42n 0.00000
+ 206.50n 0.00000 209.92n 0.00000
+ 210.00n 0.88000 213.42n 0.88000
+ 213.50n 0.88000 216.92n 0.88000
+ 217.00n 0.88000 220.42n 0.88000
+ 220.50n 0.88000 223.92n 0.88000
+ 224.00n 0.05000 227.42n 0.05000
+ 227.50n 0.05000 230.92n 0.05000
+ 231.00n 0.05000 234.42n 0.05000
+ 234.50n 0.05000 237.92n 0.05000
+ 238.00n 0.88000 241.42n 0.88000
+ 241.50n 0.88000 244.92n 0.88000
+ 245.00n 0.88000 248.42n 0.88000
+ 248.50n 0.88000 251.92n 0.88000
+ 252.00n 0.88000)
Vb08_3  b08_3   0 pwl(
+ 0.00n -0.05000 3.42n -0.05000
+ 3.50n -0.05000 6.92n -0.05000
+ 7.00n 0.72000 10.42n 0.72000
+ 10.50n 0.72000 13.92n 0.72000
+ 14.00n -0.05000 17.42n -0.05000
+ 17.50n -0.05000 20.92n -0.05000
+ 21.00n 0.72000 24.42n 0.72000
+ 24.50n 0.72000 27.92n 0.72000
+ 28.00n 0.00000 31.42n 0.00000
+ 31.50n 0.00000 34.92n 0.00000
+ 35.00n 0.72000 38.42n 0.72000
+ 38.50n 0.72000 41.92n 0.72000
+ 42.00n 0.00000 45.42n 0.00000
+ 45.50n 0.00000 48.92n 0.00000
+ 49.00n 0.72000 52.42n 0.72000
+ 52.50n 0.72000 55.92n 0.72000
+ 56.00n 0.05000 59.42n 0.05000
+ 59.50n 0.05000 62.92n 0.05000
+ 63.00n 0.72000 66.42n 0.72000
+ 66.50n 0.72000 69.92n 0.72000
+ 70.00n 0.05000 73.42n 0.05000
+ 73.50n 0.05000 76.92n 0.05000
+ 77.00n 0.72000 80.42n 0.72000
+ 80.50n 0.72000 83.92n 0.72000
+ 84.00n -0.05000 87.42n -0.05000
+ 87.50n -0.05000 90.92n -0.05000
+ 91.00n 0.80000 94.42n 0.80000
+ 94.50n 0.80000 97.92n 0.80000
+ 98.00n -0.05000 101.42n -0.05000
+ 101.50n -0.05000 104.92n -0.05000
+ 105.00n 0.80000 108.42n 0.80000
+ 108.50n 0.80000 111.92n 0.80000
+ 112.00n 0.00000 115.42n 0.00000
+ 115.50n 0.00000 118.92n 0.00000
+ 119.00n 0.80000 122.42n 0.80000
+ 122.50n 0.80000 125.92n 0.80000
+ 126.00n 0.00000 129.42n 0.00000
+ 129.50n 0.00000 132.92n 0.00000
+ 133.00n 0.80000 136.42n 0.80000
+ 136.50n 0.80000 139.92n 0.80000
+ 140.00n 0.05000 143.42n 0.05000
+ 143.50n 0.05000 146.92n 0.05000
+ 147.00n 0.80000 150.42n 0.80000
+ 150.50n 0.80000 153.92n 0.80000
+ 154.00n 0.05000 157.42n 0.05000
+ 157.50n 0.05000 160.92n 0.05000
+ 161.00n 0.80000 164.42n 0.80000
+ 164.50n 0.80000 167.92n 0.80000
+ 168.00n -0.05000 171.42n -0.05000
+ 171.50n -0.05000 174.92n -0.05000
+ 175.00n 0.88000 178.42n 0.88000
+ 178.50n 0.88000 181.92n 0.88000
+ 182.00n -0.05000 185.42n -0.05000
+ 185.50n -0.05000 188.92n -0.05000
+ 189.00n 0.88000 192.42n 0.88000
+ 192.50n 0.88000 195.92n 0.88000
+ 196.00n 0.00000 199.42n 0.00000
+ 199.50n 0.00000 202.92n 0.00000
+ 203.00n 0.88000 206.42n 0.88000
+ 206.50n 0.88000 209.92n 0.88000
+ 210.00n 0.00000 213.42n 0.00000
+ 213.50n 0.00000 216.92n 0.00000
+ 217.00n 0.88000 220.42n 0.88000
+ 220.50n 0.88000 223.92n 0.88000
+ 224.00n 0.05000 227.42n 0.05000
+ 227.50n 0.05000 230.92n 0.05000
+ 231.00n 0.88000 234.42n 0.88000
+ 234.50n 0.88000 237.92n 0.88000
+ 238.00n 0.05000 241.42n 0.05000
+ 241.50n 0.05000 244.92n 0.05000
+ 245.00n 0.88000 248.42n 0.88000
+ 248.50n 0.88000 251.92n 0.88000
+ 252.00n 0.88000)
Vc08_3  c08_3   0 pwl(
+ 0.00n -0.05000 3.42n -0.05000
+ 3.50n 0.72000 6.92n 0.72000
+ 7.00n -0.05000 10.42n -0.05000
+ 10.50n 0.72000 13.92n 0.72000
+ 14.00n -0.05000 17.42n -0.05000
+ 17.50n 0.72000 20.92n 0.72000
+ 21.00n -0.05000 24.42n -0.05000
+ 24.50n 0.72000 27.92n 0.72000
+ 28.00n 0.00000 31.42n 0.00000
+ 31.50n 0.72000 34.92n 0.72000
+ 35.00n 0.00000 38.42n 0.00000
+ 38.50n 0.72000 41.92n 0.72000
+ 42.00n 0.00000 45.42n 0.00000
+ 45.50n 0.72000 48.92n 0.72000
+ 49.00n 0.00000 52.42n 0.00000
+ 52.50n 0.72000 55.92n 0.72000
+ 56.00n 0.05000 59.42n 0.05000
+ 59.50n 0.72000 62.92n 0.72000
+ 63.00n 0.05000 66.42n 0.05000
+ 66.50n 0.72000 69.92n 0.72000
+ 70.00n 0.05000 73.42n 0.05000
+ 73.50n 0.72000 76.92n 0.72000
+ 77.00n 0.05000 80.42n 0.05000
+ 80.50n 0.72000 83.92n 0.72000
+ 84.00n -0.05000 87.42n -0.05000
+ 87.50n 0.80000 90.92n 0.80000
+ 91.00n -0.05000 94.42n -0.05000
+ 94.50n 0.80000 97.92n 0.80000
+ 98.00n -0.05000 101.42n -0.05000
+ 101.50n 0.80000 104.92n 0.80000
+ 105.00n -0.05000 108.42n -0.05000
+ 108.50n 0.80000 111.92n 0.80000
+ 112.00n 0.00000 115.42n 0.00000
+ 115.50n 0.80000 118.92n 0.80000
+ 119.00n 0.00000 122.42n 0.00000
+ 122.50n 0.80000 125.92n 0.80000
+ 126.00n 0.00000 129.42n 0.00000
+ 129.50n 0.80000 132.92n 0.80000
+ 133.00n 0.00000 136.42n 0.00000
+ 136.50n 0.80000 139.92n 0.80000
+ 140.00n 0.05000 143.42n 0.05000
+ 143.50n 0.80000 146.92n 0.80000
+ 147.00n 0.05000 150.42n 0.05000
+ 150.50n 0.80000 153.92n 0.80000
+ 154.00n 0.05000 157.42n 0.05000
+ 157.50n 0.80000 160.92n 0.80000
+ 161.00n 0.05000 164.42n 0.05000
+ 164.50n 0.80000 167.92n 0.80000
+ 168.00n -0.05000 171.42n -0.05000
+ 171.50n 0.88000 174.92n 0.88000
+ 175.00n -0.05000 178.42n -0.05000
+ 178.50n 0.88000 181.92n 0.88000
+ 182.00n -0.05000 185.42n -0.05000
+ 185.50n 0.88000 188.92n 0.88000
+ 189.00n -0.05000 192.42n -0.05000
+ 192.50n 0.88000 195.92n 0.88000
+ 196.00n 0.00000 199.42n 0.00000
+ 199.50n 0.88000 202.92n 0.88000
+ 203.00n 0.00000 206.42n 0.00000
+ 206.50n 0.88000 209.92n 0.88000
+ 210.00n 0.00000 213.42n 0.00000
+ 213.50n 0.88000 216.92n 0.88000
+ 217.00n 0.00000 220.42n 0.00000
+ 220.50n 0.88000 223.92n 0.88000
+ 224.00n 0.05000 227.42n 0.05000
+ 227.50n 0.88000 230.92n 0.88000
+ 231.00n 0.05000 234.42n 0.05000
+ 234.50n 0.88000 237.92n 0.88000
+ 238.00n 0.05000 241.42n 0.05000
+ 241.50n 0.88000 244.92n 0.88000
+ 245.00n 0.05000 248.42n 0.05000
+ 248.50n 0.88000 251.92n 0.88000
+ 252.00n 0.88000)
Va11_3  a11_3   0 pwl(
+ 0.00n -0.05000 3.42n -0.05000
+ 3.50n -0.05000 6.92n -0.05000
+ 7.00n -0.05000 10.42n -0.05000
+ 10.50n -0.05000 13.92n -0.05000
+ 14.00n 0.99000 17.42n 0.99000
+ 17.50n 0.99000 20.92n 0.99000
+ 21.00n 0.99000 24.42n 0.99000
+ 24.50n 0.99000 27.92n 0.99000
+ 28.00n 0.00000 31.42n 0.00000
+ 31.50n 0.00000 34.92n 0.00000
+ 35.00n 0.00000 38.42n 0.00000
+ 38.50n 0.00000 41.92n 0.00000
+ 42.00n 0.99000 45.42n 0.99000
+ 45.50n 0.99000 48.92n 0.99000
+ 49.00n 0.99000 52.42n 0.99000
+ 52.50n 0.99000 55.92n 0.99000
+ 56.00n 0.05000 59.42n 0.05000
+ 59.50n 0.05000 62.92n 0.05000
+ 63.00n 0.05000 66.42n 0.05000
+ 66.50n 0.05000 69.92n 0.05000
+ 70.00n 0.99000 73.42n 0.99000
+ 73.50n 0.99000 76.92n 0.99000
+ 77.00n 0.99000 80.42n 0.99000
+ 80.50n 0.99000 83.92n 0.99000
+ 84.00n -0.05000 87.42n -0.05000
+ 87.50n -0.05000 90.92n -0.05000
+ 91.00n -0.05000 94.42n -0.05000
+ 94.50n -0.05000 97.92n -0.05000
+ 98.00n 1.10000 101.42n 1.10000
+ 101.50n 1.10000 104.92n 1.10000
+ 105.00n 1.10000 108.42n 1.10000
+ 108.50n 1.10000 111.92n 1.10000
+ 112.00n 0.00000 115.42n 0.00000
+ 115.50n 0.00000 118.92n 0.00000
+ 119.00n 0.00000 122.42n 0.00000
+ 122.50n 0.00000 125.92n 0.00000
+ 126.00n 1.10000 129.42n 1.10000
+ 129.50n 1.10000 132.92n 1.10000
+ 133.00n 1.10000 136.42n 1.10000
+ 136.50n 1.10000 139.92n 1.10000
+ 140.00n 0.05000 143.42n 0.05000
+ 143.50n 0.05000 146.92n 0.05000
+ 147.00n 0.05000 150.42n 0.05000
+ 150.50n 0.05000 153.92n 0.05000
+ 154.00n 1.10000 157.42n 1.10000
+ 157.50n 1.10000 160.92n 1.10000
+ 161.00n 1.10000 164.42n 1.10000
+ 164.50n 1.10000 167.92n 1.10000
+ 168.00n -0.05000 171.42n -0.05000
+ 171.50n -0.05000 174.92n -0.05000
+ 175.00n -0.05000 178.42n -0.05000
+ 178.50n -0.05000 181.92n -0.05000
+ 182.00n 1.21000 185.42n 1.21000
+ 185.50n 1.21000 188.92n 1.21000
+ 189.00n 1.21000 192.42n 1.21000
+ 192.50n 1.21000 195.92n 1.21000
+ 196.00n 0.00000 199.42n 0.00000
+ 199.50n 0.00000 202.92n 0.00000
+ 203.00n 0.00000 206.42n 0.00000
+ 206.50n 0.00000 209.92n 0.00000
+ 210.00n 1.21000 213.42n 1.21000
+ 213.50n 1.21000 216.92n 1.21000
+ 217.00n 1.21000 220.42n 1.21000
+ 220.50n 1.21000 223.92n 1.21000
+ 224.00n 0.05000 227.42n 0.05000
+ 227.50n 0.05000 230.92n 0.05000
+ 231.00n 0.05000 234.42n 0.05000
+ 234.50n 0.05000 237.92n 0.05000
+ 238.00n 1.21000 241.42n 1.21000
+ 241.50n 1.21000 244.92n 1.21000
+ 245.00n 1.21000 248.42n 1.21000
+ 248.50n 1.21000 251.92n 1.21000
+ 252.00n 1.21000)
Van11_3 an11_3  0 pwl(
+ 0.00n 0.99000 3.42n 0.99000
+ 3.50n 0.99000 6.92n 0.99000
+ 7.00n 0.99000 10.42n 0.99000
+ 10.50n 0.99000 13.92n 0.99000
+ 14.00n -0.05000 17.42n -0.05000
+ 17.50n -0.05000 20.92n -0.05000
+ 21.00n -0.05000 24.42n -0.05000
+ 24.50n -0.05000 27.92n -0.05000
+ 28.00n 0.99000 31.42n 0.99000
+ 31.50n 0.99000 34.92n 0.99000
+ 35.00n 0.99000 38.42n 0.99000
+ 38.50n 0.99000 41.92n 0.99000
+ 42.00n 0.00000 45.42n 0.00000
+ 45.50n 0.00000 48.92n 0.00000
+ 49.00n 0.00000 52.42n 0.00000
+ 52.50n 0.00000 55.92n 0.00000
+ 56.00n 0.99000 59.42n 0.99000
+ 59.50n 0.99000 62.92n 0.99000
+ 63.00n 0.99000 66.42n 0.99000
+ 66.50n 0.99000 69.92n 0.99000
+ 70.00n 0.05000 73.42n 0.05000
+ 73.50n 0.05000 76.92n 0.05000
+ 77.00n 0.05000 80.42n 0.05000
+ 80.50n 0.05000 83.92n 0.05000
+ 84.00n 1.10000 87.42n 1.10000
+ 87.50n 1.10000 90.92n 1.10000
+ 91.00n 1.10000 94.42n 1.10000
+ 94.50n 1.10000 97.92n 1.10000
+ 98.00n -0.05000 101.42n -0.05000
+ 101.50n -0.05000 104.92n -0.05000
+ 105.00n -0.05000 108.42n -0.05000
+ 108.50n -0.05000 111.92n -0.05000
+ 112.00n 1.10000 115.42n 1.10000
+ 115.50n 1.10000 118.92n 1.10000
+ 119.00n 1.10000 122.42n 1.10000
+ 122.50n 1.10000 125.92n 1.10000
+ 126.00n 0.00000 129.42n 0.00000
+ 129.50n 0.00000 132.92n 0.00000
+ 133.00n 0.00000 136.42n 0.00000
+ 136.50n 0.00000 139.92n 0.00000
+ 140.00n 1.10000 143.42n 1.10000
+ 143.50n 1.10000 146.92n 1.10000
+ 147.00n 1.10000 150.42n 1.10000
+ 150.50n 1.10000 153.92n 1.10000
+ 154.00n 0.05000 157.42n 0.05000
+ 157.50n 0.05000 160.92n 0.05000
+ 161.00n 0.05000 164.42n 0.05000
+ 164.50n 0.05000 167.92n 0.05000
+ 168.00n 1.21000 171.42n 1.21000
+ 171.50n 1.21000 174.92n 1.21000
+ 175.00n 1.21000 178.42n 1.21000
+ 178.50n 1.21000 181.92n 1.21000
+ 182.00n -0.05000 185.42n -0.05000
+ 185.50n -0.05000 188.92n -0.05000
+ 189.00n -0.05000 192.42n -0.05000
+ 192.50n -0.05000 195.92n -0.05000
+ 196.00n 1.21000 199.42n 1.21000
+ 199.50n 1.21000 202.92n 1.21000
+ 203.00n 1.21000 206.42n 1.21000
+ 206.50n 1.21000 209.92n 1.21000
+ 210.00n 0.00000 213.42n 0.00000
+ 213.50n 0.00000 216.92n 0.00000
+ 217.00n 0.00000 220.42n 0.00000
+ 220.50n 0.00000 223.92n 0.00000
+ 224.00n 1.21000 227.42n 1.21000
+ 227.50n 1.21000 230.92n 1.21000
+ 231.00n 1.21000 234.42n 1.21000
+ 234.50n 1.21000 237.92n 1.21000
+ 238.00n 0.05000 241.42n 0.05000
+ 241.50n 0.05000 244.92n 0.05000
+ 245.00n 0.05000 248.42n 0.05000
+ 248.50n 0.05000 251.92n 0.05000
+ 252.00n 0.05000)
Vb11_3  b11_3   0 pwl(
+ 0.00n -0.05000 3.42n -0.05000
+ 3.50n -0.05000 6.92n -0.05000
+ 7.00n 0.99000 10.42n 0.99000
+ 10.50n 0.99000 13.92n 0.99000
+ 14.00n -0.05000 17.42n -0.05000
+ 17.50n -0.05000 20.92n -0.05000
+ 21.00n 0.99000 24.42n 0.99000
+ 24.50n 0.99000 27.92n 0.99000
+ 28.00n 0.00000 31.42n 0.00000
+ 31.50n 0.00000 34.92n 0.00000
+ 35.00n 0.99000 38.42n 0.99000
+ 38.50n 0.99000 41.92n 0.99000
+ 42.00n 0.00000 45.42n 0.00000
+ 45.50n 0.00000 48.92n 0.00000
+ 49.00n 0.99000 52.42n 0.99000
+ 52.50n 0.99000 55.92n 0.99000
+ 56.00n 0.05000 59.42n 0.05000
+ 59.50n 0.05000 62.92n 0.05000
+ 63.00n 0.99000 66.42n 0.99000
+ 66.50n 0.99000 69.92n 0.99000
+ 70.00n 0.05000 73.42n 0.05000
+ 73.50n 0.05000 76.92n 0.05000
+ 77.00n 0.99000 80.42n 0.99000
+ 80.50n 0.99000 83.92n 0.99000
+ 84.00n -0.05000 87.42n -0.05000
+ 87.50n -0.05000 90.92n -0.05000
+ 91.00n 1.10000 94.42n 1.10000
+ 94.50n 1.10000 97.92n 1.10000
+ 98.00n -0.05000 101.42n -0.05000
+ 101.50n -0.05000 104.92n -0.05000
+ 105.00n 1.10000 108.42n 1.10000
+ 108.50n 1.10000 111.92n 1.10000
+ 112.00n 0.00000 115.42n 0.00000
+ 115.50n 0.00000 118.92n 0.00000
+ 119.00n 1.10000 122.42n 1.10000
+ 122.50n 1.10000 125.92n 1.10000
+ 126.00n 0.00000 129.42n 0.00000
+ 129.50n 0.00000 132.92n 0.00000
+ 133.00n 1.10000 136.42n 1.10000
+ 136.50n 1.10000 139.92n 1.10000
+ 140.00n 0.05000 143.42n 0.05000
+ 143.50n 0.05000 146.92n 0.05000
+ 147.00n 1.10000 150.42n 1.10000
+ 150.50n 1.10000 153.92n 1.10000
+ 154.00n 0.05000 157.42n 0.05000
+ 157.50n 0.05000 160.92n 0.05000
+ 161.00n 1.10000 164.42n 1.10000
+ 164.50n 1.10000 167.92n 1.10000
+ 168.00n -0.05000 171.42n -0.05000
+ 171.50n -0.05000 174.92n -0.05000
+ 175.00n 1.21000 178.42n 1.21000
+ 178.50n 1.21000 181.92n 1.21000
+ 182.00n -0.05000 185.42n -0.05000
+ 185.50n -0.05000 188.92n -0.05000
+ 189.00n 1.21000 192.42n 1.21000
+ 192.50n 1.21000 195.92n 1.21000
+ 196.00n 0.00000 199.42n 0.00000
+ 199.50n 0.00000 202.92n 0.00000
+ 203.00n 1.21000 206.42n 1.21000
+ 206.50n 1.21000 209.92n 1.21000
+ 210.00n 0.00000 213.42n 0.00000
+ 213.50n 0.00000 216.92n 0.00000
+ 217.00n 1.21000 220.42n 1.21000
+ 220.50n 1.21000 223.92n 1.21000
+ 224.00n 0.05000 227.42n 0.05000
+ 227.50n 0.05000 230.92n 0.05000
+ 231.00n 1.21000 234.42n 1.21000
+ 234.50n 1.21000 237.92n 1.21000
+ 238.00n 0.05000 241.42n 0.05000
+ 241.50n 0.05000 244.92n 0.05000
+ 245.00n 1.21000 248.42n 1.21000
+ 248.50n 1.21000 251.92n 1.21000
+ 252.00n 1.21000)
Vbn11_3 bn11_3  0 pwl(
+ 0.00n 0.99000 3.42n 0.99000
+ 3.50n 0.99000 6.92n 0.99000
+ 7.00n -0.05000 10.42n -0.05000
+ 10.50n -0.05000 13.92n -0.05000
+ 14.00n 0.99000 17.42n 0.99000
+ 17.50n 0.99000 20.92n 0.99000
+ 21.00n -0.05000 24.42n -0.05000
+ 24.50n -0.05000 27.92n -0.05000
+ 28.00n 0.99000 31.42n 0.99000
+ 31.50n 0.99000 34.92n 0.99000
+ 35.00n 0.00000 38.42n 0.00000
+ 38.50n 0.00000 41.92n 0.00000
+ 42.00n 0.99000 45.42n 0.99000
+ 45.50n 0.99000 48.92n 0.99000
+ 49.00n 0.00000 52.42n 0.00000
+ 52.50n 0.00000 55.92n 0.00000
+ 56.00n 0.99000 59.42n 0.99000
+ 59.50n 0.99000 62.92n 0.99000
+ 63.00n 0.05000 66.42n 0.05000
+ 66.50n 0.05000 69.92n 0.05000
+ 70.00n 0.99000 73.42n 0.99000
+ 73.50n 0.99000 76.92n 0.99000
+ 77.00n 0.05000 80.42n 0.05000
+ 80.50n 0.05000 83.92n 0.05000
+ 84.00n 1.10000 87.42n 1.10000
+ 87.50n 1.10000 90.92n 1.10000
+ 91.00n -0.05000 94.42n -0.05000
+ 94.50n -0.05000 97.92n -0.05000
+ 98.00n 1.10000 101.42n 1.10000
+ 101.50n 1.10000 104.92n 1.10000
+ 105.00n -0.05000 108.42n -0.05000
+ 108.50n -0.05000 111.92n -0.05000
+ 112.00n 1.10000 115.42n 1.10000
+ 115.50n 1.10000 118.92n 1.10000
+ 119.00n 0.00000 122.42n 0.00000
+ 122.50n 0.00000 125.92n 0.00000
+ 126.00n 1.10000 129.42n 1.10000
+ 129.50n 1.10000 132.92n 1.10000
+ 133.00n 0.00000 136.42n 0.00000
+ 136.50n 0.00000 139.92n 0.00000
+ 140.00n 1.10000 143.42n 1.10000
+ 143.50n 1.10000 146.92n 1.10000
+ 147.00n 0.05000 150.42n 0.05000
+ 150.50n 0.05000 153.92n 0.05000
+ 154.00n 1.10000 157.42n 1.10000
+ 157.50n 1.10000 160.92n 1.10000
+ 161.00n 0.05000 164.42n 0.05000
+ 164.50n 0.05000 167.92n 0.05000
+ 168.00n 1.21000 171.42n 1.21000
+ 171.50n 1.21000 174.92n 1.21000
+ 175.00n -0.05000 178.42n -0.05000
+ 178.50n -0.05000 181.92n -0.05000
+ 182.00n 1.21000 185.42n 1.21000
+ 185.50n 1.21000 188.92n 1.21000
+ 189.00n -0.05000 192.42n -0.05000
+ 192.50n -0.05000 195.92n -0.05000
+ 196.00n 1.21000 199.42n 1.21000
+ 199.50n 1.21000 202.92n 1.21000
+ 203.00n 0.00000 206.42n 0.00000
+ 206.50n 0.00000 209.92n 0.00000
+ 210.00n 1.21000 213.42n 1.21000
+ 213.50n 1.21000 216.92n 1.21000
+ 217.00n 0.00000 220.42n 0.00000
+ 220.50n 0.00000 223.92n 0.00000
+ 224.00n 1.21000 227.42n 1.21000
+ 227.50n 1.21000 230.92n 1.21000
+ 231.00n 0.05000 234.42n 0.05000
+ 234.50n 0.05000 237.92n 0.05000
+ 238.00n 1.21000 241.42n 1.21000
+ 241.50n 1.21000 244.92n 1.21000
+ 245.00n 0.05000 248.42n 0.05000
+ 248.50n 0.05000 251.92n 0.05000
+ 252.00n 0.05000)
Vc11_3  c11_3   0 pwl(
+ 0.00n -0.05000 3.42n -0.05000
+ 3.50n 0.99000 6.92n 0.99000
+ 7.00n -0.05000 10.42n -0.05000
+ 10.50n 0.99000 13.92n 0.99000
+ 14.00n -0.05000 17.42n -0.05000
+ 17.50n 0.99000 20.92n 0.99000
+ 21.00n -0.05000 24.42n -0.05000
+ 24.50n 0.99000 27.92n 0.99000
+ 28.00n 0.00000 31.42n 0.00000
+ 31.50n 0.99000 34.92n 0.99000
+ 35.00n 0.00000 38.42n 0.00000
+ 38.50n 0.99000 41.92n 0.99000
+ 42.00n 0.00000 45.42n 0.00000
+ 45.50n 0.99000 48.92n 0.99000
+ 49.00n 0.00000 52.42n 0.00000
+ 52.50n 0.99000 55.92n 0.99000
+ 56.00n 0.05000 59.42n 0.05000
+ 59.50n 0.99000 62.92n 0.99000
+ 63.00n 0.05000 66.42n 0.05000
+ 66.50n 0.99000 69.92n 0.99000
+ 70.00n 0.05000 73.42n 0.05000
+ 73.50n 0.99000 76.92n 0.99000
+ 77.00n 0.05000 80.42n 0.05000
+ 80.50n 0.99000 83.92n 0.99000
+ 84.00n -0.05000 87.42n -0.05000
+ 87.50n 1.10000 90.92n 1.10000
+ 91.00n -0.05000 94.42n -0.05000
+ 94.50n 1.10000 97.92n 1.10000
+ 98.00n -0.05000 101.42n -0.05000
+ 101.50n 1.10000 104.92n 1.10000
+ 105.00n -0.05000 108.42n -0.05000
+ 108.50n 1.10000 111.92n 1.10000
+ 112.00n 0.00000 115.42n 0.00000
+ 115.50n 1.10000 118.92n 1.10000
+ 119.00n 0.00000 122.42n 0.00000
+ 122.50n 1.10000 125.92n 1.10000
+ 126.00n 0.00000 129.42n 0.00000
+ 129.50n 1.10000 132.92n 1.10000
+ 133.00n 0.00000 136.42n 0.00000
+ 136.50n 1.10000 139.92n 1.10000
+ 140.00n 0.05000 143.42n 0.05000
+ 143.50n 1.10000 146.92n 1.10000
+ 147.00n 0.05000 150.42n 0.05000
+ 150.50n 1.10000 153.92n 1.10000
+ 154.00n 0.05000 157.42n 0.05000
+ 157.50n 1.10000 160.92n 1.10000
+ 161.00n 0.05000 164.42n 0.05000
+ 164.50n 1.10000 167.92n 1.10000
+ 168.00n -0.05000 171.42n -0.05000
+ 171.50n 1.21000 174.92n 1.21000
+ 175.00n -0.05000 178.42n -0.05000
+ 178.50n 1.21000 181.92n 1.21000
+ 182.00n -0.05000 185.42n -0.05000
+ 185.50n 1.21000 188.92n 1.21000
+ 189.00n -0.05000 192.42n -0.05000
+ 192.50n 1.21000 195.92n 1.21000
+ 196.00n 0.00000 199.42n 0.00000
+ 199.50n 1.21000 202.92n 1.21000
+ 203.00n 0.00000 206.42n 0.00000
+ 206.50n 1.21000 209.92n 1.21000
+ 210.00n 0.00000 213.42n 0.00000
+ 213.50n 1.21000 216.92n 1.21000
+ 217.00n 0.00000 220.42n 0.00000
+ 220.50n 1.21000 223.92n 1.21000
+ 224.00n 0.05000 227.42n 0.05000
+ 227.50n 1.21000 230.92n 1.21000
+ 231.00n 0.05000 234.42n 0.05000
+ 234.50n 1.21000 237.92n 1.21000
+ 238.00n 0.05000 241.42n 0.05000
+ 241.50n 1.21000 244.92n 1.21000
+ 245.00n 0.05000 248.42n 0.05000
+ 248.50n 1.21000 251.92n 1.21000
+ 252.00n 1.21000)
Vcn11_3 cn11_3  0 pwl(
+ 0.00n 0.99000 3.42n 0.99000
+ 3.50n -0.05000 6.92n -0.05000
+ 7.00n 0.99000 10.42n 0.99000
+ 10.50n -0.05000 13.92n -0.05000
+ 14.00n 0.99000 17.42n 0.99000
+ 17.50n -0.05000 20.92n -0.05000
+ 21.00n 0.99000 24.42n 0.99000
+ 24.50n -0.05000 27.92n -0.05000
+ 28.00n 0.99000 31.42n 0.99000
+ 31.50n 0.00000 34.92n 0.00000
+ 35.00n 0.99000 38.42n 0.99000
+ 38.50n 0.00000 41.92n 0.00000
+ 42.00n 0.99000 45.42n 0.99000
+ 45.50n 0.00000 48.92n 0.00000
+ 49.00n 0.99000 52.42n 0.99000
+ 52.50n 0.00000 55.92n 0.00000
+ 56.00n 0.99000 59.42n 0.99000
+ 59.50n 0.05000 62.92n 0.05000
+ 63.00n 0.99000 66.42n 0.99000
+ 66.50n 0.05000 69.92n 0.05000
+ 70.00n 0.99000 73.42n 0.99000
+ 73.50n 0.05000 76.92n 0.05000
+ 77.00n 0.99000 80.42n 0.99000
+ 80.50n 0.05000 83.92n 0.05000
+ 84.00n 1.10000 87.42n 1.10000
+ 87.50n -0.05000 90.92n -0.05000
+ 91.00n 1.10000 94.42n 1.10000
+ 94.50n -0.05000 97.92n -0.05000
+ 98.00n 1.10000 101.42n 1.10000
+ 101.50n -0.05000 104.92n -0.05000
+ 105.00n 1.10000 108.42n 1.10000
+ 108.50n -0.05000 111.92n -0.05000
+ 112.00n 1.10000 115.42n 1.10000
+ 115.50n 0.00000 118.92n 0.00000
+ 119.00n 1.10000 122.42n 1.10000
+ 122.50n 0.00000 125.92n 0.00000
+ 126.00n 1.10000 129.42n 1.10000
+ 129.50n 0.00000 132.92n 0.00000
+ 133.00n 1.10000 136.42n 1.10000
+ 136.50n 0.00000 139.92n 0.00000
+ 140.00n 1.10000 143.42n 1.10000
+ 143.50n 0.05000 146.92n 0.05000
+ 147.00n 1.10000 150.42n 1.10000
+ 150.50n 0.05000 153.92n 0.05000
+ 154.00n 1.10000 157.42n 1.10000
+ 157.50n 0.05000 160.92n 0.05000
+ 161.00n 1.10000 164.42n 1.10000
+ 164.50n 0.05000 167.92n 0.05000
+ 168.00n 1.21000 171.42n 1.21000
+ 171.50n -0.05000 174.92n -0.05000
+ 175.00n 1.21000 178.42n 1.21000
+ 178.50n -0.05000 181.92n -0.05000
+ 182.00n 1.21000 185.42n 1.21000
+ 185.50n -0.05000 188.92n -0.05000
+ 189.00n 1.21000 192.42n 1.21000
+ 192.50n -0.05000 195.92n -0.05000
+ 196.00n 1.21000 199.42n 1.21000
+ 199.50n 0.00000 202.92n 0.00000
+ 203.00n 1.21000 206.42n 1.21000
+ 206.50n 0.00000 209.92n 0.00000
+ 210.00n 1.21000 213.42n 1.21000
+ 213.50n 0.00000 216.92n 0.00000
+ 217.00n 1.21000 220.42n 1.21000
+ 220.50n 0.00000 223.92n 0.00000
+ 224.00n 1.21000 227.42n 1.21000
+ 227.50n 0.05000 230.92n 0.05000
+ 231.00n 1.21000 234.42n 1.21000
+ 234.50n 0.05000 237.92n 0.05000
+ 238.00n 1.21000 241.42n 1.21000
+ 241.50n 0.05000 244.92n 0.05000
+ 245.00n 1.21000 248.42n 1.21000
+ 248.50n 0.05000 251.92n 0.05000
+ 252.00n 0.05000)

B_rt08_3 rtop08_3 0 V = (mode_k < 0.5) ? v(vdd08_3) : v(vss_3)
B_gta_3  gtop_a_3 0 V = (mode_k < 0.5) ? v(gta_k0_3) : v(vdd08_3)
B_rb08_3 rbot08_3 0 V = (mode_k < 0.5) ? v(vss_3)   : v(vdd08_3)
B_gba_3  gbot_a_3 0 V = (mode_k < 0.5) ? v(vdd08_3) : v(gb08_k1_3)

B_rt15_3 rtop15_3 0 V = (mode_k < 0.5) ? v(vss_3)   : v(vdd15_3)
B_gt15_3 gtop15_3 0 V = (mode_k < 0.5) ? 0.8        : v(vss_3)
B_rb15_3 rbot15_3 0 V = (mode_k < 0.5) ? v(vdd15_3) : v(vss_3)
B_gb15_3 gbot15_3 0 V = (mode_k < 0.5) ? v(vss_3)   : 0.8
B_k_3    k_3      0 V = (mode_k < 0.5) ? v(vss_3)   : v(vdd11_3)
B_kn_3   kn_3     0 V = (mode_k < 0.5) ? v(vdd11_3) : v(vss_3)

* 6) (AOI21, OAI21)
XAOI1 ntop_aoi a08_3 rtop08_3 gtop_a_3 gtop_a_3 ARI W=1.5
XAOI2 ntop_aoi b08_3 rtop08_3 gtop_a_3 gtop_a_3 ARI W=1.5
XAOI3 out_aoi  c08_3 ntop_aoi gtop_a_3 gtop_a_3 ARI W=2.5
XAOI4 out_aoi  b08_3 nbot_aoi gbot_a_3 gbot_a_3 ARI W=2.5
XAOI5 nbot_aoi a08_3 rbot08_3 gbot_a_3 gbot_a_3 ARI W=2.5
XAOI6 out_aoi  c08_3 rbot08_3 gbot_a_3 gbot_a_3 ARI W=1.5
Cnt_aoi  ntop_aoi 0 0.05f
Cnb_aoi  nbot_aoi 0 0.05f
Cout_aoi out_aoi  0 0.3f

* 7) (MAJ3, XOR3)
XX_PRE a11_3 an11_3 b11_3 bn11_3 p_raw vdd15_3 vss_3 vss_3 gn POLY_XOR
Cp_raw p_raw 0 0.2f
XI_P1  p_raw pn08 vdd08_3 vss_3 BP_INV08
XI_P2  pn08  p08  vdd08_3 vss_3 BP_INV08
XI_P3  p08   pn11 vdd11_3 vss_3 BP_INV11
XI_P4  pn08  p11  vdd11_3 vss_3 BP_INV11

XM2  out_mx p11  rtop15_3 cn11_3 gtop15_3 ARI W=1.0
XM4  out_mx pn11 rbot15_3 cn11_3 gbot15_3 ARI W=1.0
XM1a out_mx pn11 n1a_mx   an11_3 gn       ARI W=2.0
XM1b n1a_mx kn_3 vss_3    kn_3   gn       ARI W=2.0
XM1c out_mx pn11 n1c_mx   c11_3  vss_3    ARI W=2.0
XM1d n1c_mx kn_3 vdd15_3  kn_3   vss_3    ARI W=2.0
XM3a out_mx p11  n3a_mx   an11_3 vss_3    ARI W=2.0
XM3b n3a_mx k_3  vdd15_3  k_3    vss_3    ARI W=2.0
XM3c out_mx p11  n3c_mx   c11_3  gn       ARI W=2.0
XM3d n3c_mx k_3  vss_3    k_3    gn       ARI W=2.0
Cn1a_mx n1a_mx 0 0.05f
Cn1c_mx n1c_mx 0 0.05f
Cn3a_mx n3a_mx 0 0.05f
Cn3c_mx n3c_mx 0 0.05f
Cout_mx out_mx 0 0.3f

.control
set wr_vecnames
set wr_singlescale

tran 50p 252.0n
wrdata rob_k0.dat v(out_nn) v(out_xx) v(out_ao) v(out_nx) v(out_rx) v(out_aoi) v(out_mx)

alterparam mode_k = 1
reset
tran 50p 252.0n
wrdata rob_k1.dat v(out_nn) v(out_xx) v(out_ao) v(out_nx) v(out_rx) v(out_aoi) v(out_mx)
.endc
.end
