* Varredura de Tensoes Nao-Padronizadas — Porta Polimorfica NAND/NOR 4T
.include "../00_modelo_ngspice/bp_ari_ngspice.lib"

Vrtop rtop 0 pwl(
+ 0.00n 0.8  9.80n 0.8
+ 10.00n 0.8  19.80n 0.8
+ 20.00n 0.8  29.80n 0.8
+ 30.00n 0.8  39.80n 0.8
+ 40.00n 0.8  49.80n 0.8
+ 50.00n 0.8  59.80n 0.8
+ 60.00n 0.8  69.80n 0.8
+ 70.00n 0.8  79.80n 0.8
+ 80.00n 0.8  89.80n 0.8
+ 90.00n 0.8  99.80n 0.8
+ 100.00n 0.8  109.80n 0.8
+ 110.00n 0.8  119.80n 0.8
+ 120.00n 0.8  129.80n 0.8
+ 130.00n 0.8  139.80n 0.8
+ 140.00n 0.8  149.80n 0.8
+ 150.00n 0.8  159.80n 0.8
+ 160.00n 0.8  169.80n 0.8
+ 170.00n 0.8  179.80n 0.8
+ 180.00n 0.8  189.80n 0.8
+ 190.00n 0.8  199.80n 0.8
+ 200.00n 0.8  209.80n 0.8
+ 210.00n 0.8  219.80n 0.8
+ 220.00n 0.8  229.80n 0.8
+ 230.00n 0.8  239.80n 0.8
+ 240.00n 0.8  249.80n 0.8
+ 250.00n 0.8  259.80n 0.8
+ 260.00n 0.8  269.80n 0.8
+ 270.00n 0.8  279.80n 0.8
+ 280.00n 0.8  289.80n 0.8
+ 290.00n 0.8  299.80n 0.8
+ 300.00n 0.8  309.80n 0.8
+ 310.00n 0.8  319.80n 0.8
+ 320.00n 0.8  329.80n 0.8
+ 330.00n 0.8  339.80n 0.8
+ 340.00n 0.8  349.80n 0.8
+ 350.00n 0.8  359.80n 0.8
+ 360.00n 0  369.80n 0
+ 370.00n 0  379.80n 0
+ 380.00n 0  389.80n 0
+ 390.00n 0  399.80n 0
+ 400.00n 0  409.80n 0
+ 410.00n 0  419.80n 0
+ 420.00n 0  429.80n 0
+ 430.00n 0  439.80n 0
+ 440.00n 0  449.80n 0
+ 450.00n 0  459.80n 0
+ 460.00n 0  469.80n 0
+ 470.00n 0  479.80n 0
+ 480.00n 0  489.80n 0
+ 490.00n 0  499.80n 0
+ 500.00n 0  509.80n 0
+ 510.00n 0  519.80n 0
+ 520.00n 0  529.80n 0
+ 530.00n 0  539.80n 0
+ 540.00n 0  549.80n 0
+ 550.00n 0  559.80n 0
+ 560.00n 0  569.80n 0
+ 570.00n 0  579.80n 0
+ 580.00n 0  589.80n 0
+ 590.00n 0  599.80n 0
+ 600.00n 0  609.80n 0
+ 610.00n 0  619.80n 0
+ 620.00n 0  629.80n 0
+ 630.00n 0  639.80n 0
+ 640.00n 0  649.80n 0
+ 650.00n 0  659.80n 0
+ 660.00n 0  669.80n 0
+ 670.00n 0  679.80n 0
+ 680.00n 0  689.80n 0
+ 690.00n 0  699.80n 0
+ 700.00n 0  709.80n 0
+ 710.00n 0  719.80n 0
+ 720.00n 0)
Vrbot rbot 0 pwl(
+ 0.00n 0  9.80n 0
+ 10.00n 0  19.80n 0
+ 20.00n 0  29.80n 0
+ 30.00n 0  39.80n 0
+ 40.00n 0  49.80n 0
+ 50.00n 0  59.80n 0
+ 60.00n 0  69.80n 0
+ 70.00n 0  79.80n 0
+ 80.00n 0  89.80n 0
+ 90.00n 0  99.80n 0
+ 100.00n 0  109.80n 0
+ 110.00n 0  119.80n 0
+ 120.00n 0  129.80n 0
+ 130.00n 0  139.80n 0
+ 140.00n 0  149.80n 0
+ 150.00n 0  159.80n 0
+ 160.00n 0  169.80n 0
+ 170.00n 0  179.80n 0
+ 180.00n 0  189.80n 0
+ 190.00n 0  199.80n 0
+ 200.00n 0  209.80n 0
+ 210.00n 0  219.80n 0
+ 220.00n 0  229.80n 0
+ 230.00n 0  239.80n 0
+ 240.00n 0  249.80n 0
+ 250.00n 0  259.80n 0
+ 260.00n 0  269.80n 0
+ 270.00n 0  279.80n 0
+ 280.00n 0  289.80n 0
+ 290.00n 0  299.80n 0
+ 300.00n 0  309.80n 0
+ 310.00n 0  319.80n 0
+ 320.00n 0  329.80n 0
+ 330.00n 0  339.80n 0
+ 340.00n 0  349.80n 0
+ 350.00n 0  359.80n 0
+ 360.00n 0.8  369.80n 0.8
+ 370.00n 0.8  379.80n 0.8
+ 380.00n 0.8  389.80n 0.8
+ 390.00n 0.8  399.80n 0.8
+ 400.00n 0.8  409.80n 0.8
+ 410.00n 0.8  419.80n 0.8
+ 420.00n 0.8  429.80n 0.8
+ 430.00n 0.8  439.80n 0.8
+ 440.00n 0.8  449.80n 0.8
+ 450.00n 0.8  459.80n 0.8
+ 460.00n 0.8  469.80n 0.8
+ 470.00n 0.8  479.80n 0.8
+ 480.00n 0.8  489.80n 0.8
+ 490.00n 0.8  499.80n 0.8
+ 500.00n 0.8  509.80n 0.8
+ 510.00n 0.8  519.80n 0.8
+ 520.00n 0.8  529.80n 0.8
+ 530.00n 0.8  539.80n 0.8
+ 540.00n 0.8  549.80n 0.8
+ 550.00n 0.8  559.80n 0.8
+ 560.00n 0.8  569.80n 0.8
+ 570.00n 0.8  579.80n 0.8
+ 580.00n 0.8  589.80n 0.8
+ 590.00n 0.8  599.80n 0.8
+ 600.00n 0.8  609.80n 0.8
+ 610.00n 0.8  619.80n 0.8
+ 620.00n 0.8  629.80n 0.8
+ 630.00n 0.8  639.80n 0.8
+ 640.00n 0.8  649.80n 0.8
+ 650.00n 0.8  659.80n 0.8
+ 660.00n 0.8  669.80n 0.8
+ 670.00n 0.8  679.80n 0.8
+ 680.00n 0.8  689.80n 0.8
+ 690.00n 0.8  699.80n 0.8
+ 700.00n 0.8  709.80n 0.8
+ 710.00n 0.8  719.80n 0.8
+ 720.00n 0.8)
Vgtop gtop 0 pwl(
+ 0.00n -0.1  9.80n -0.1
+ 10.00n -0.2  19.80n -0.2
+ 20.00n -0.3  29.80n -0.3
+ 30.00n -0.4  39.80n -0.4
+ 40.00n -0.55  49.80n -0.55
+ 50.00n -0.7  59.80n -0.7
+ 60.00n -0.1  69.80n -0.1
+ 70.00n -0.2  79.80n -0.2
+ 80.00n -0.3  89.80n -0.3
+ 90.00n -0.4  99.80n -0.4
+ 100.00n -0.55  109.80n -0.55
+ 110.00n -0.7  119.80n -0.7
+ 120.00n -0.1  129.80n -0.1
+ 130.00n -0.2  139.80n -0.2
+ 140.00n -0.3  149.80n -0.3
+ 150.00n -0.4  159.80n -0.4
+ 160.00n -0.55  169.80n -0.55
+ 170.00n -0.7  179.80n -0.7
+ 180.00n -0.1  189.80n -0.1
+ 190.00n -0.2  199.80n -0.2
+ 200.00n -0.3  209.80n -0.3
+ 210.00n -0.4  219.80n -0.4
+ 220.00n -0.55  229.80n -0.55
+ 230.00n -0.7  239.80n -0.7
+ 240.00n -0.1  249.80n -0.1
+ 250.00n -0.2  259.80n -0.2
+ 260.00n -0.3  269.80n -0.3
+ 270.00n -0.4  279.80n -0.4
+ 280.00n -0.55  289.80n -0.55
+ 290.00n -0.7  299.80n -0.7
+ 300.00n -0.1  309.80n -0.1
+ 310.00n -0.2  319.80n -0.2
+ 320.00n -0.3  329.80n -0.3
+ 330.00n -0.4  339.80n -0.4
+ 340.00n -0.55  349.80n -0.55
+ 350.00n -0.7  359.80n -0.7
+ 360.00n 0.2  369.80n 0.2
+ 370.00n 0.2  379.80n 0.2
+ 380.00n 0.2  389.80n 0.2
+ 390.00n 0.2  399.80n 0.2
+ 400.00n 0.2  409.80n 0.2
+ 410.00n 0.2  419.80n 0.2
+ 420.00n 0.3  429.80n 0.3
+ 430.00n 0.3  439.80n 0.3
+ 440.00n 0.3  449.80n 0.3
+ 450.00n 0.3  459.80n 0.3
+ 460.00n 0.3  469.80n 0.3
+ 470.00n 0.3  479.80n 0.3
+ 480.00n 0.4  489.80n 0.4
+ 490.00n 0.4  499.80n 0.4
+ 500.00n 0.4  509.80n 0.4
+ 510.00n 0.4  519.80n 0.4
+ 520.00n 0.4  529.80n 0.4
+ 530.00n 0.4  539.80n 0.4
+ 540.00n 0.6  549.80n 0.6
+ 550.00n 0.6  559.80n 0.6
+ 560.00n 0.6  569.80n 0.6
+ 570.00n 0.6  579.80n 0.6
+ 580.00n 0.6  589.80n 0.6
+ 590.00n 0.6  599.80n 0.6
+ 600.00n 0.8  609.80n 0.8
+ 610.00n 0.8  619.80n 0.8
+ 620.00n 0.8  629.80n 0.8
+ 630.00n 0.8  639.80n 0.8
+ 640.00n 0.8  649.80n 0.8
+ 650.00n 0.8  659.80n 0.8
+ 660.00n 1  669.80n 1
+ 670.00n 1  679.80n 1
+ 680.00n 1  689.80n 1
+ 690.00n 1  699.80n 1
+ 700.00n 1  709.80n 1
+ 710.00n 1  719.80n 1
+ 720.00n 1)
Vgbot gbot 0 pwl(
+ 0.00n 0.2  9.80n 0.2
+ 10.00n 0.2  19.80n 0.2
+ 20.00n 0.2  29.80n 0.2
+ 30.00n 0.2  39.80n 0.2
+ 40.00n 0.2  49.80n 0.2
+ 50.00n 0.2  59.80n 0.2
+ 60.00n 0.3  69.80n 0.3
+ 70.00n 0.3  79.80n 0.3
+ 80.00n 0.3  89.80n 0.3
+ 90.00n 0.3  99.80n 0.3
+ 100.00n 0.3  109.80n 0.3
+ 110.00n 0.3  119.80n 0.3
+ 120.00n 0.4  129.80n 0.4
+ 130.00n 0.4  139.80n 0.4
+ 140.00n 0.4  149.80n 0.4
+ 150.00n 0.4  159.80n 0.4
+ 160.00n 0.4  169.80n 0.4
+ 170.00n 0.4  179.80n 0.4
+ 180.00n 0.6  189.80n 0.6
+ 190.00n 0.6  199.80n 0.6
+ 200.00n 0.6  209.80n 0.6
+ 210.00n 0.6  219.80n 0.6
+ 220.00n 0.6  229.80n 0.6
+ 230.00n 0.6  239.80n 0.6
+ 240.00n 0.8  249.80n 0.8
+ 250.00n 0.8  259.80n 0.8
+ 260.00n 0.8  269.80n 0.8
+ 270.00n 0.8  279.80n 0.8
+ 280.00n 0.8  289.80n 0.8
+ 290.00n 0.8  299.80n 0.8
+ 300.00n 1  309.80n 1
+ 310.00n 1  319.80n 1
+ 320.00n 1  329.80n 1
+ 330.00n 1  339.80n 1
+ 340.00n 1  349.80n 1
+ 350.00n 1  359.80n 1
+ 360.00n -0.1  369.80n -0.1
+ 370.00n -0.2  379.80n -0.2
+ 380.00n -0.3  389.80n -0.3
+ 390.00n -0.4  399.80n -0.4
+ 400.00n -0.55  409.80n -0.55
+ 410.00n -0.7  419.80n -0.7
+ 420.00n -0.1  429.80n -0.1
+ 430.00n -0.2  439.80n -0.2
+ 440.00n -0.3  449.80n -0.3
+ 450.00n -0.4  459.80n -0.4
+ 460.00n -0.55  469.80n -0.55
+ 470.00n -0.7  479.80n -0.7
+ 480.00n -0.1  489.80n -0.1
+ 490.00n -0.2  499.80n -0.2
+ 500.00n -0.3  509.80n -0.3
+ 510.00n -0.4  519.80n -0.4
+ 520.00n -0.55  529.80n -0.55
+ 530.00n -0.7  539.80n -0.7
+ 540.00n -0.1  549.80n -0.1
+ 550.00n -0.2  559.80n -0.2
+ 560.00n -0.3  569.80n -0.3
+ 570.00n -0.4  579.80n -0.4
+ 580.00n -0.55  589.80n -0.55
+ 590.00n -0.7  599.80n -0.7
+ 600.00n -0.1  609.80n -0.1
+ 610.00n -0.2  619.80n -0.2
+ 620.00n -0.3  629.80n -0.3
+ 630.00n -0.4  639.80n -0.4
+ 640.00n -0.55  649.80n -0.55
+ 650.00n -0.7  659.80n -0.7
+ 660.00n -0.1  669.80n -0.1
+ 670.00n -0.2  679.80n -0.2
+ 680.00n -0.3  689.80n -0.3
+ 690.00n -0.4  699.80n -0.4
+ 700.00n -0.55  709.80n -0.55
+ 710.00n -0.7  719.80n -0.7
+ 720.00n -0.7)
Vvhi vhi 0 pwl(
+ 0.00n 0.8  9.80n 0.8
+ 10.00n 0.8  19.80n 0.8
+ 20.00n 0.8  29.80n 0.8
+ 30.00n 0.8  39.80n 0.8
+ 40.00n 0.8  49.80n 0.8
+ 50.00n 0.8  59.80n 0.8
+ 60.00n 0.8  69.80n 0.8
+ 70.00n 0.8  79.80n 0.8
+ 80.00n 0.8  89.80n 0.8
+ 90.00n 0.8  99.80n 0.8
+ 100.00n 0.8  109.80n 0.8
+ 110.00n 0.8  119.80n 0.8
+ 120.00n 0.8  129.80n 0.8
+ 130.00n 0.8  139.80n 0.8
+ 140.00n 0.8  149.80n 0.8
+ 150.00n 0.8  159.80n 0.8
+ 160.00n 0.8  169.80n 0.8
+ 170.00n 0.8  179.80n 0.8
+ 180.00n 0.8  189.80n 0.8
+ 190.00n 0.8  199.80n 0.8
+ 200.00n 0.8  209.80n 0.8
+ 210.00n 0.8  219.80n 0.8
+ 220.00n 0.8  229.80n 0.8
+ 230.00n 0.8  239.80n 0.8
+ 240.00n 0.8  249.80n 0.8
+ 250.00n 0.8  259.80n 0.8
+ 260.00n 0.8  269.80n 0.8
+ 270.00n 0.8  279.80n 0.8
+ 280.00n 0.8  289.80n 0.8
+ 290.00n 0.8  299.80n 0.8
+ 300.00n 0.8  309.80n 0.8
+ 310.00n 0.8  319.80n 0.8
+ 320.00n 0.8  329.80n 0.8
+ 330.00n 0.8  339.80n 0.8
+ 340.00n 0.8  349.80n 0.8
+ 350.00n 0.8  359.80n 0.8
+ 360.00n 0.8  369.80n 0.8
+ 370.00n 0.8  379.80n 0.8
+ 380.00n 0.8  389.80n 0.8
+ 390.00n 0.8  399.80n 0.8
+ 400.00n 0.8  409.80n 0.8
+ 410.00n 0.8  419.80n 0.8
+ 420.00n 0.8  429.80n 0.8
+ 430.00n 0.8  439.80n 0.8
+ 440.00n 0.8  449.80n 0.8
+ 450.00n 0.8  459.80n 0.8
+ 460.00n 0.8  469.80n 0.8
+ 470.00n 0.8  479.80n 0.8
+ 480.00n 0.8  489.80n 0.8
+ 490.00n 0.8  499.80n 0.8
+ 500.00n 0.8  509.80n 0.8
+ 510.00n 0.8  519.80n 0.8
+ 520.00n 0.8  529.80n 0.8
+ 530.00n 0.8  539.80n 0.8
+ 540.00n 0.8  549.80n 0.8
+ 550.00n 0.8  559.80n 0.8
+ 560.00n 0.8  569.80n 0.8
+ 570.00n 0.8  579.80n 0.8
+ 580.00n 0.8  589.80n 0.8
+ 590.00n 0.8  599.80n 0.8
+ 600.00n 0.8  609.80n 0.8
+ 610.00n 0.8  619.80n 0.8
+ 620.00n 0.8  629.80n 0.8
+ 630.00n 0.8  639.80n 0.8
+ 640.00n 0.8  649.80n 0.8
+ 650.00n 0.8  659.80n 0.8
+ 660.00n 0.8  669.80n 0.8
+ 670.00n 0.8  679.80n 0.8
+ 680.00n 0.8  689.80n 0.8
+ 690.00n 0.8  699.80n 0.8
+ 700.00n 0.8  709.80n 0.8
+ 710.00n 0.8  719.80n 0.8
+ 720.00n 0.8)
Vlo vlo 0 0.0

* Padrao 00 (A=0, B=0)
X00_1 out00 vlo rtop gtop gtop ARI W=1.0
X00_2 out00 vlo rtop gtop gtop ARI W=1.0
X00_3 out00 vlo n00  gbot gbot ARI W=2.0
X00_4 n00   vlo rbot gbot gbot ARI W=2.0
C00_o out00 0 0.2f
C00_n n00   0 0.1f

* Padrao 01 (A=0, B=VDD)
X01_1 out01 vlo rtop gtop gtop ARI W=1.0
X01_2 out01 vhi rtop gtop gtop ARI W=1.0
X01_3 out01 vhi n01  gbot gbot ARI W=2.0
X01_4 n01   vlo rbot gbot gbot ARI W=2.0
C01_o out01 0 0.2f
C01_n n01   0 0.1f

* Padrao 10 (A=VDD, B=0)
X10_1 out10 vhi rtop gtop gtop ARI W=1.0
X10_2 out10 vlo rtop gtop gtop ARI W=1.0
X10_3 out10 vlo n10  gbot gbot ARI W=2.0
X10_4 n10   vhi rbot gbot gbot ARI W=2.0
C10_o out10 0 0.2f
C10_n n10   0 0.1f

* Padrao 11 (A=VDD, B=VDD)
X11_1 out11 vhi rtop gtop gtop ARI W=1.0
X11_2 out11 vhi rtop gtop gtop ARI W=1.0
X11_3 out11 vhi n11  gbot gbot ARI W=2.0
X11_4 n11   vhi rbot gbot gbot ARI W=2.0
C11_o out11 0 0.2f
C11_n n11   0 0.1f

.control
set wr_vecnames
set wr_singlescale
tran 100p 720.0n
wrdata sweep_nand_nor_asym.dat v(out00) v(out01) v(out10) v(out11) i(Vrtop) i(Vrbot)
.endc
.end
