* Varredura de Tensoes Nao-Padronizadas — Porta Polimorfica XOR/XNOR 4T
.include "../00_modelo_ngspice/bp_ari_ngspice.lib"

Vrtop rtop 0 pwl(
+ 0.00n 0.6  9.80n 0.6
+ 10.00n 0.6  19.80n 0.6
+ 20.00n 0.6  29.80n 0.6
+ 30.00n 0.6  39.80n 0.6
+ 40.00n 0.6  49.80n 0.6
+ 50.00n 0.8  59.80n 0.8
+ 60.00n 0.8  69.80n 0.8
+ 70.00n 0.8  79.80n 0.8
+ 80.00n 0.8  89.80n 0.8
+ 90.00n 0.8  99.80n 0.8
+ 100.00n 1  109.80n 1
+ 110.00n 1  119.80n 1
+ 120.00n 1  129.80n 1
+ 130.00n 1  139.80n 1
+ 140.00n 1  149.80n 1
+ 150.00n 1.2  159.80n 1.2
+ 160.00n 1.2  169.80n 1.2
+ 170.00n 1.2  179.80n 1.2
+ 180.00n 1.2  189.80n 1.2
+ 190.00n 1.2  199.80n 1.2
+ 200.00n 1.5  209.80n 1.5
+ 210.00n 1.5  219.80n 1.5
+ 220.00n 1.5  229.80n 1.5
+ 230.00n 1.5  239.80n 1.5
+ 240.00n 1.5  249.80n 1.5
+ 250.00n 0  259.80n 0
+ 260.00n 0  269.80n 0
+ 270.00n 0  279.80n 0
+ 280.00n 0  289.80n 0
+ 290.00n 0  299.80n 0
+ 300.00n 0  309.80n 0
+ 310.00n 0  319.80n 0
+ 320.00n 0  329.80n 0
+ 330.00n 0  339.80n 0
+ 340.00n 0  349.80n 0
+ 350.00n 0  359.80n 0
+ 360.00n 0  369.80n 0
+ 370.00n 0  379.80n 0
+ 380.00n 0  389.80n 0
+ 390.00n 0  399.80n 0
+ 400.00n 0  409.80n 0
+ 410.00n 0  419.80n 0
+ 420.00n 0  429.80n 0
+ 430.00n 0  439.80n 0
+ 440.00n 0  449.80n 0
+ 450.00n 0  459.80n 0
+ 460.00n 0  469.80n 0
+ 470.00n 0  479.80n 0
+ 480.00n 0  489.80n 0
+ 490.00n 0  499.80n 0
+ 500.00n 0.6  509.80n 0.6
+ 510.00n 0.6  519.80n 0.6
+ 520.00n 0.6  529.80n 0.6
+ 530.00n 0.6  539.80n 0.6
+ 540.00n 0.6  549.80n 0.6
+ 550.00n 0.8  559.80n 0.8
+ 560.00n 0.8  569.80n 0.8
+ 570.00n 0.8  579.80n 0.8
+ 580.00n 0.8  589.80n 0.8
+ 590.00n 0.8  599.80n 0.8
+ 600.00n 1  609.80n 1
+ 610.00n 1  619.80n 1
+ 620.00n 1  629.80n 1
+ 630.00n 1  639.80n 1
+ 640.00n 1  649.80n 1
+ 650.00n 1.2  659.80n 1.2
+ 660.00n 1.2  669.80n 1.2
+ 670.00n 1.2  679.80n 1.2
+ 680.00n 1.2  689.80n 1.2
+ 690.00n 1.2  699.80n 1.2
+ 700.00n 1.5  709.80n 1.5
+ 710.00n 1.5  719.80n 1.5
+ 720.00n 1.5  729.80n 1.5
+ 730.00n 1.5  739.80n 1.5
+ 740.00n 1.5  749.80n 1.5
+ 750.00n 0  759.80n 0
+ 760.00n 0  769.80n 0
+ 770.00n 0  779.80n 0
+ 780.00n 0  789.80n 0
+ 790.00n 0  799.80n 0
+ 800.00n 0  809.80n 0
+ 810.00n 0  819.80n 0
+ 820.00n 0  829.80n 0
+ 830.00n 0  839.80n 0
+ 840.00n 0  849.80n 0
+ 850.00n 0  859.80n 0
+ 860.00n 0  869.80n 0
+ 870.00n 0  879.80n 0
+ 880.00n 0  889.80n 0
+ 890.00n 0  899.80n 0
+ 900.00n 0  909.80n 0
+ 910.00n 0  919.80n 0
+ 920.00n 0  929.80n 0
+ 930.00n 0  939.80n 0
+ 940.00n 0  949.80n 0
+ 950.00n 0  959.80n 0
+ 960.00n 0  969.80n 0
+ 970.00n 0  979.80n 0
+ 980.00n 0  989.80n 0
+ 990.00n 0  999.80n 0
+ 1000.00n 0.9  1009.80n 0.9
+ 1010.00n 0.9  1019.80n 0.9
+ 1020.00n 0.9  1029.80n 0.9
+ 1030.00n 0.9  1039.80n 0.9
+ 1040.00n 0.9  1049.80n 0.9
+ 1050.00n 1  1059.80n 1
+ 1060.00n 1  1069.80n 1
+ 1070.00n 1  1079.80n 1
+ 1080.00n 1  1089.80n 1
+ 1090.00n 1  1099.80n 1
+ 1100.00n 1.2  1109.80n 1.2
+ 1110.00n 1.2  1119.80n 1.2
+ 1120.00n 1.2  1129.80n 1.2
+ 1130.00n 1.2  1139.80n 1.2
+ 1140.00n 1.2  1149.80n 1.2
+ 1150.00n 1.35  1159.80n 1.35
+ 1160.00n 1.35  1169.80n 1.35
+ 1170.00n 1.35  1179.80n 1.35
+ 1180.00n 1.35  1189.80n 1.35
+ 1190.00n 1.35  1199.80n 1.35
+ 1200.00n 1.5  1209.80n 1.5
+ 1210.00n 1.5  1219.80n 1.5
+ 1220.00n 1.5  1229.80n 1.5
+ 1230.00n 1.5  1239.80n 1.5
+ 1240.00n 1.5  1249.80n 1.5
+ 1250.00n 0  1259.80n 0
+ 1260.00n 0  1269.80n 0
+ 1270.00n 0  1279.80n 0
+ 1280.00n 0  1289.80n 0
+ 1290.00n 0  1299.80n 0
+ 1300.00n 0  1309.80n 0
+ 1310.00n 0  1319.80n 0
+ 1320.00n 0  1329.80n 0
+ 1330.00n 0  1339.80n 0
+ 1340.00n 0  1349.80n 0
+ 1350.00n 0  1359.80n 0
+ 1360.00n 0  1369.80n 0
+ 1370.00n 0  1379.80n 0
+ 1380.00n 0  1389.80n 0
+ 1390.00n 0  1399.80n 0
+ 1400.00n 0  1409.80n 0
+ 1410.00n 0  1419.80n 0
+ 1420.00n 0  1429.80n 0
+ 1430.00n 0  1439.80n 0
+ 1440.00n 0  1449.80n 0
+ 1450.00n 0  1459.80n 0
+ 1460.00n 0  1469.80n 0
+ 1470.00n 0  1479.80n 0
+ 1480.00n 0  1489.80n 0
+ 1490.00n 0  1499.80n 0
+ 1500.00n 0)
Vrbot rbot 0 pwl(
+ 0.00n 0  9.80n 0
+ 10.00n 0  19.80n 0
+ 20.00n 0  29.80n 0
+ 30.00n 0  39.80n 0
+ 40.00n 0  49.80n 0
+ 50.00n 0  59.80n 0
+ 60.00n 0  69.80n 0
+ 70.00n 0  79.80n 0
+ 80.00n 0  89.80n 0
+ 90.00n 0  99.80n 0
+ 100.00n 0  109.80n 0
+ 110.00n 0  119.80n 0
+ 120.00n 0  129.80n 0
+ 130.00n 0  139.80n 0
+ 140.00n 0  149.80n 0
+ 150.00n 0  159.80n 0
+ 160.00n 0  169.80n 0
+ 170.00n 0  179.80n 0
+ 180.00n 0  189.80n 0
+ 190.00n 0  199.80n 0
+ 200.00n 0  209.80n 0
+ 210.00n 0  219.80n 0
+ 220.00n 0  229.80n 0
+ 230.00n 0  239.80n 0
+ 240.00n 0  249.80n 0
+ 250.00n 0.6  259.80n 0.6
+ 260.00n 0.6  269.80n 0.6
+ 270.00n 0.6  279.80n 0.6
+ 280.00n 0.6  289.80n 0.6
+ 290.00n 0.6  299.80n 0.6
+ 300.00n 0.8  309.80n 0.8
+ 310.00n 0.8  319.80n 0.8
+ 320.00n 0.8  329.80n 0.8
+ 330.00n 0.8  339.80n 0.8
+ 340.00n 0.8  349.80n 0.8
+ 350.00n 1  359.80n 1
+ 360.00n 1  369.80n 1
+ 370.00n 1  379.80n 1
+ 380.00n 1  389.80n 1
+ 390.00n 1  399.80n 1
+ 400.00n 1.2  409.80n 1.2
+ 410.00n 1.2  419.80n 1.2
+ 420.00n 1.2  429.80n 1.2
+ 430.00n 1.2  439.80n 1.2
+ 440.00n 1.2  449.80n 1.2
+ 450.00n 1.5  459.80n 1.5
+ 460.00n 1.5  469.80n 1.5
+ 470.00n 1.5  479.80n 1.5
+ 480.00n 1.5  489.80n 1.5
+ 490.00n 1.5  499.80n 1.5
+ 500.00n 0  509.80n 0
+ 510.00n 0  519.80n 0
+ 520.00n 0  529.80n 0
+ 530.00n 0  539.80n 0
+ 540.00n 0  549.80n 0
+ 550.00n 0  559.80n 0
+ 560.00n 0  569.80n 0
+ 570.00n 0  579.80n 0
+ 580.00n 0  589.80n 0
+ 590.00n 0  599.80n 0
+ 600.00n 0  609.80n 0
+ 610.00n 0  619.80n 0
+ 620.00n 0  629.80n 0
+ 630.00n 0  639.80n 0
+ 640.00n 0  649.80n 0
+ 650.00n 0  659.80n 0
+ 660.00n 0  669.80n 0
+ 670.00n 0  679.80n 0
+ 680.00n 0  689.80n 0
+ 690.00n 0  699.80n 0
+ 700.00n 0  709.80n 0
+ 710.00n 0  719.80n 0
+ 720.00n 0  729.80n 0
+ 730.00n 0  739.80n 0
+ 740.00n 0  749.80n 0
+ 750.00n 0.6  759.80n 0.6
+ 760.00n 0.6  769.80n 0.6
+ 770.00n 0.6  779.80n 0.6
+ 780.00n 0.6  789.80n 0.6
+ 790.00n 0.6  799.80n 0.6
+ 800.00n 0.8  809.80n 0.8
+ 810.00n 0.8  819.80n 0.8
+ 820.00n 0.8  829.80n 0.8
+ 830.00n 0.8  839.80n 0.8
+ 840.00n 0.8  849.80n 0.8
+ 850.00n 1  859.80n 1
+ 860.00n 1  869.80n 1
+ 870.00n 1  879.80n 1
+ 880.00n 1  889.80n 1
+ 890.00n 1  899.80n 1
+ 900.00n 1.2  909.80n 1.2
+ 910.00n 1.2  919.80n 1.2
+ 920.00n 1.2  929.80n 1.2
+ 930.00n 1.2  939.80n 1.2
+ 940.00n 1.2  949.80n 1.2
+ 950.00n 1.5  959.80n 1.5
+ 960.00n 1.5  969.80n 1.5
+ 970.00n 1.5  979.80n 1.5
+ 980.00n 1.5  989.80n 1.5
+ 990.00n 1.5  999.80n 1.5
+ 1000.00n 0  1009.80n 0
+ 1010.00n 0  1019.80n 0
+ 1020.00n 0  1029.80n 0
+ 1030.00n 0  1039.80n 0
+ 1040.00n 0  1049.80n 0
+ 1050.00n 0  1059.80n 0
+ 1060.00n 0  1069.80n 0
+ 1070.00n 0  1079.80n 0
+ 1080.00n 0  1089.80n 0
+ 1090.00n 0  1099.80n 0
+ 1100.00n 0  1109.80n 0
+ 1110.00n 0  1119.80n 0
+ 1120.00n 0  1129.80n 0
+ 1130.00n 0  1139.80n 0
+ 1140.00n 0  1149.80n 0
+ 1150.00n 0  1159.80n 0
+ 1160.00n 0  1169.80n 0
+ 1170.00n 0  1179.80n 0
+ 1180.00n 0  1189.80n 0
+ 1190.00n 0  1199.80n 0
+ 1200.00n 0  1209.80n 0
+ 1210.00n 0  1219.80n 0
+ 1220.00n 0  1229.80n 0
+ 1230.00n 0  1239.80n 0
+ 1240.00n 0  1249.80n 0
+ 1250.00n 0.9  1259.80n 0.9
+ 1260.00n 0.9  1269.80n 0.9
+ 1270.00n 0.9  1279.80n 0.9
+ 1280.00n 0.9  1289.80n 0.9
+ 1290.00n 0.9  1299.80n 0.9
+ 1300.00n 1  1309.80n 1
+ 1310.00n 1  1319.80n 1
+ 1320.00n 1  1329.80n 1
+ 1330.00n 1  1339.80n 1
+ 1340.00n 1  1349.80n 1
+ 1350.00n 1.2  1359.80n 1.2
+ 1360.00n 1.2  1369.80n 1.2
+ 1370.00n 1.2  1379.80n 1.2
+ 1380.00n 1.2  1389.80n 1.2
+ 1390.00n 1.2  1399.80n 1.2
+ 1400.00n 1.35  1409.80n 1.35
+ 1410.00n 1.35  1419.80n 1.35
+ 1420.00n 1.35  1429.80n 1.35
+ 1430.00n 1.35  1439.80n 1.35
+ 1440.00n 1.35  1449.80n 1.35
+ 1450.00n 1.5  1459.80n 1.5
+ 1460.00n 1.5  1469.80n 1.5
+ 1470.00n 1.5  1479.80n 1.5
+ 1480.00n 1.5  1489.80n 1.5
+ 1490.00n 1.5  1499.80n 1.5
+ 1500.00n 1.5)
Vgtop gtop 0 pwl(
+ 0.00n -0.9  9.80n -0.9
+ 10.00n -0.9  19.80n -0.9
+ 20.00n -0.9  29.80n -0.9
+ 30.00n -0.9  39.80n -0.9
+ 40.00n -0.9  49.80n -0.9
+ 50.00n -0.7  59.80n -0.7
+ 60.00n -0.7  69.80n -0.7
+ 70.00n -0.7  79.80n -0.7
+ 80.00n -0.7  89.80n -0.7
+ 90.00n -0.7  99.80n -0.7
+ 100.00n -0.5  109.80n -0.5
+ 110.00n -0.5  119.80n -0.5
+ 120.00n -0.5  129.80n -0.5
+ 130.00n -0.5  139.80n -0.5
+ 140.00n -0.5  149.80n -0.5
+ 150.00n -0.3  159.80n -0.3
+ 160.00n -0.3  169.80n -0.3
+ 170.00n -0.3  179.80n -0.3
+ 180.00n -0.3  189.80n -0.3
+ 190.00n -0.3  199.80n -0.3
+ 200.00n 0  209.80n 0
+ 210.00n 0  219.80n 0
+ 220.00n 0  229.80n 0
+ 230.00n 0  239.80n 0
+ 240.00n 0  249.80n 0
+ 250.00n 0.8  259.80n 0.8
+ 260.00n 0.8  269.80n 0.8
+ 270.00n 0.8  279.80n 0.8
+ 280.00n 0.8  289.80n 0.8
+ 290.00n 0.8  299.80n 0.8
+ 300.00n 0.8  309.80n 0.8
+ 310.00n 0.8  319.80n 0.8
+ 320.00n 0.8  329.80n 0.8
+ 330.00n 0.8  339.80n 0.8
+ 340.00n 0.8  349.80n 0.8
+ 350.00n 0.8  359.80n 0.8
+ 360.00n 0.8  369.80n 0.8
+ 370.00n 0.8  379.80n 0.8
+ 380.00n 0.8  389.80n 0.8
+ 390.00n 0.8  399.80n 0.8
+ 400.00n 0.8  409.80n 0.8
+ 410.00n 0.8  419.80n 0.8
+ 420.00n 0.8  429.80n 0.8
+ 430.00n 0.8  439.80n 0.8
+ 440.00n 0.8  449.80n 0.8
+ 450.00n 0.8  459.80n 0.8
+ 460.00n 0.8  469.80n 0.8
+ 470.00n 0.8  479.80n 0.8
+ 480.00n 0.8  489.80n 0.8
+ 490.00n 0.8  499.80n 0.8
+ 500.00n -0.3  509.80n -0.3
+ 510.00n -0.3  519.80n -0.3
+ 520.00n -0.3  529.80n -0.3
+ 530.00n -0.3  539.80n -0.3
+ 540.00n -0.3  549.80n -0.3
+ 550.00n -0.1  559.80n -0.1
+ 560.00n -0.1  569.80n -0.1
+ 570.00n -0.1  579.80n -0.1
+ 580.00n -0.1  589.80n -0.1
+ 590.00n -0.1  599.80n -0.1
+ 600.00n 0.1  609.80n 0.1
+ 610.00n 0.1  619.80n 0.1
+ 620.00n 0.1  629.80n 0.1
+ 630.00n 0.1  639.80n 0.1
+ 640.00n 0.1  649.80n 0.1
+ 650.00n 0.3  659.80n 0.3
+ 660.00n 0.3  669.80n 0.3
+ 670.00n 0.3  679.80n 0.3
+ 680.00n 0.3  689.80n 0.3
+ 690.00n 0.3  699.80n 0.3
+ 700.00n 0.6  709.80n 0.6
+ 710.00n 0.6  719.80n 0.6
+ 720.00n 0.6  729.80n 0.6
+ 730.00n 0.6  739.80n 0.6
+ 740.00n 0.6  749.80n 0.6
+ 750.00n 0.2  759.80n 0.2
+ 760.00n 0.2  769.80n 0.2
+ 770.00n 0.2  779.80n 0.2
+ 780.00n 0.2  789.80n 0.2
+ 790.00n 0.2  799.80n 0.2
+ 800.00n 0.2  809.80n 0.2
+ 810.00n 0.2  819.80n 0.2
+ 820.00n 0.2  829.80n 0.2
+ 830.00n 0.2  839.80n 0.2
+ 840.00n 0.2  849.80n 0.2
+ 850.00n 0.2  859.80n 0.2
+ 860.00n 0.2  869.80n 0.2
+ 870.00n 0.2  879.80n 0.2
+ 880.00n 0.2  889.80n 0.2
+ 890.00n 0.2  899.80n 0.2
+ 900.00n 0.2  909.80n 0.2
+ 910.00n 0.2  919.80n 0.2
+ 920.00n 0.2  929.80n 0.2
+ 930.00n 0.2  939.80n 0.2
+ 940.00n 0.2  949.80n 0.2
+ 950.00n 0.2  959.80n 0.2
+ 960.00n 0.2  969.80n 0.2
+ 970.00n 0.2  979.80n 0.2
+ 980.00n 0.2  989.80n 0.2
+ 990.00n 0.2  999.80n 0.2
+ 1000.00n 0  1009.80n 0
+ 1010.00n 0  1019.80n 0
+ 1020.00n 0  1029.80n 0
+ 1030.00n 0  1039.80n 0
+ 1040.00n 0  1049.80n 0
+ 1050.00n 0  1059.80n 0
+ 1060.00n 0  1069.80n 0
+ 1070.00n 0  1079.80n 0
+ 1080.00n 0  1089.80n 0
+ 1090.00n 0  1099.80n 0
+ 1100.00n 0  1109.80n 0
+ 1110.00n 0  1119.80n 0
+ 1120.00n 0  1129.80n 0
+ 1130.00n 0  1139.80n 0
+ 1140.00n 0  1149.80n 0
+ 1150.00n 0  1159.80n 0
+ 1160.00n 0  1169.80n 0
+ 1170.00n 0  1179.80n 0
+ 1180.00n 0  1189.80n 0
+ 1190.00n 0  1199.80n 0
+ 1200.00n 0  1209.80n 0
+ 1210.00n 0  1219.80n 0
+ 1220.00n 0  1229.80n 0
+ 1230.00n 0  1239.80n 0
+ 1240.00n 0  1249.80n 0
+ 1250.00n 0.8  1259.80n 0.8
+ 1260.00n 0.8  1269.80n 0.8
+ 1270.00n 0.8  1279.80n 0.8
+ 1280.00n 0.8  1289.80n 0.8
+ 1290.00n 0.8  1299.80n 0.8
+ 1300.00n 0.8  1309.80n 0.8
+ 1310.00n 0.8  1319.80n 0.8
+ 1320.00n 0.8  1329.80n 0.8
+ 1330.00n 0.8  1339.80n 0.8
+ 1340.00n 0.8  1349.80n 0.8
+ 1350.00n 0.8  1359.80n 0.8
+ 1360.00n 0.8  1369.80n 0.8
+ 1370.00n 0.8  1379.80n 0.8
+ 1380.00n 0.8  1389.80n 0.8
+ 1390.00n 0.8  1399.80n 0.8
+ 1400.00n 0.8  1409.80n 0.8
+ 1410.00n 0.8  1419.80n 0.8
+ 1420.00n 0.8  1429.80n 0.8
+ 1430.00n 0.8  1439.80n 0.8
+ 1440.00n 0.8  1449.80n 0.8
+ 1450.00n 0.8  1459.80n 0.8
+ 1460.00n 0.8  1469.80n 0.8
+ 1470.00n 0.8  1479.80n 0.8
+ 1480.00n 0.8  1489.80n 0.8
+ 1490.00n 0.8  1499.80n 0.8
+ 1500.00n 0.8)
Vgbot gbot 0 pwl(
+ 0.00n 0.8  9.80n 0.8
+ 10.00n 0.8  19.80n 0.8
+ 20.00n 0.8  29.80n 0.8
+ 30.00n 0.8  39.80n 0.8
+ 40.00n 0.8  49.80n 0.8
+ 50.00n 0.8  59.80n 0.8
+ 60.00n 0.8  69.80n 0.8
+ 70.00n 0.8  79.80n 0.8
+ 80.00n 0.8  89.80n 0.8
+ 90.00n 0.8  99.80n 0.8
+ 100.00n 0.8  109.80n 0.8
+ 110.00n 0.8  119.80n 0.8
+ 120.00n 0.8  129.80n 0.8
+ 130.00n 0.8  139.80n 0.8
+ 140.00n 0.8  149.80n 0.8
+ 150.00n 0.8  159.80n 0.8
+ 160.00n 0.8  169.80n 0.8
+ 170.00n 0.8  179.80n 0.8
+ 180.00n 0.8  189.80n 0.8
+ 190.00n 0.8  199.80n 0.8
+ 200.00n 0.8  209.80n 0.8
+ 210.00n 0.8  219.80n 0.8
+ 220.00n 0.8  229.80n 0.8
+ 230.00n 0.8  239.80n 0.8
+ 240.00n 0.8  249.80n 0.8
+ 250.00n -0.9  259.80n -0.9
+ 260.00n -0.9  269.80n -0.9
+ 270.00n -0.9  279.80n -0.9
+ 280.00n -0.9  289.80n -0.9
+ 290.00n -0.9  299.80n -0.9
+ 300.00n -0.7  309.80n -0.7
+ 310.00n -0.7  319.80n -0.7
+ 320.00n -0.7  329.80n -0.7
+ 330.00n -0.7  339.80n -0.7
+ 340.00n -0.7  349.80n -0.7
+ 350.00n -0.5  359.80n -0.5
+ 360.00n -0.5  369.80n -0.5
+ 370.00n -0.5  379.80n -0.5
+ 380.00n -0.5  389.80n -0.5
+ 390.00n -0.5  399.80n -0.5
+ 400.00n -0.3  409.80n -0.3
+ 410.00n -0.3  419.80n -0.3
+ 420.00n -0.3  429.80n -0.3
+ 430.00n -0.3  439.80n -0.3
+ 440.00n -0.3  449.80n -0.3
+ 450.00n 0  459.80n 0
+ 460.00n 0  469.80n 0
+ 470.00n 0  479.80n 0
+ 480.00n 0  489.80n 0
+ 490.00n 0  499.80n 0
+ 500.00n 0.2  509.80n 0.2
+ 510.00n 0.2  519.80n 0.2
+ 520.00n 0.2  529.80n 0.2
+ 530.00n 0.2  539.80n 0.2
+ 540.00n 0.2  549.80n 0.2
+ 550.00n 0.2  559.80n 0.2
+ 560.00n 0.2  569.80n 0.2
+ 570.00n 0.2  579.80n 0.2
+ 580.00n 0.2  589.80n 0.2
+ 590.00n 0.2  599.80n 0.2
+ 600.00n 0.2  609.80n 0.2
+ 610.00n 0.2  619.80n 0.2
+ 620.00n 0.2  629.80n 0.2
+ 630.00n 0.2  639.80n 0.2
+ 640.00n 0.2  649.80n 0.2
+ 650.00n 0.2  659.80n 0.2
+ 660.00n 0.2  669.80n 0.2
+ 670.00n 0.2  679.80n 0.2
+ 680.00n 0.2  689.80n 0.2
+ 690.00n 0.2  699.80n 0.2
+ 700.00n 0.2  709.80n 0.2
+ 710.00n 0.2  719.80n 0.2
+ 720.00n 0.2  729.80n 0.2
+ 730.00n 0.2  739.80n 0.2
+ 740.00n 0.2  749.80n 0.2
+ 750.00n -0.3  759.80n -0.3
+ 760.00n -0.3  769.80n -0.3
+ 770.00n -0.3  779.80n -0.3
+ 780.00n -0.3  789.80n -0.3
+ 790.00n -0.3  799.80n -0.3
+ 800.00n -0.1  809.80n -0.1
+ 810.00n -0.1  819.80n -0.1
+ 820.00n -0.1  829.80n -0.1
+ 830.00n -0.1  839.80n -0.1
+ 840.00n -0.1  849.80n -0.1
+ 850.00n 0.1  859.80n 0.1
+ 860.00n 0.1  869.80n 0.1
+ 870.00n 0.1  879.80n 0.1
+ 880.00n 0.1  889.80n 0.1
+ 890.00n 0.1  899.80n 0.1
+ 900.00n 0.3  909.80n 0.3
+ 910.00n 0.3  919.80n 0.3
+ 920.00n 0.3  929.80n 0.3
+ 930.00n 0.3  939.80n 0.3
+ 940.00n 0.3  949.80n 0.3
+ 950.00n 0.6  959.80n 0.6
+ 960.00n 0.6  969.80n 0.6
+ 970.00n 0.6  979.80n 0.6
+ 980.00n 0.6  989.80n 0.6
+ 990.00n 0.6  999.80n 0.6
+ 1000.00n 0.8  1009.80n 0.8
+ 1010.00n 0.8  1019.80n 0.8
+ 1020.00n 0.8  1029.80n 0.8
+ 1030.00n 0.8  1039.80n 0.8
+ 1040.00n 0.8  1049.80n 0.8
+ 1050.00n 0.8  1059.80n 0.8
+ 1060.00n 0.8  1069.80n 0.8
+ 1070.00n 0.8  1079.80n 0.8
+ 1080.00n 0.8  1089.80n 0.8
+ 1090.00n 0.8  1099.80n 0.8
+ 1100.00n 0.8  1109.80n 0.8
+ 1110.00n 0.8  1119.80n 0.8
+ 1120.00n 0.8  1129.80n 0.8
+ 1130.00n 0.8  1139.80n 0.8
+ 1140.00n 0.8  1149.80n 0.8
+ 1150.00n 0.8  1159.80n 0.8
+ 1160.00n 0.8  1169.80n 0.8
+ 1170.00n 0.8  1179.80n 0.8
+ 1180.00n 0.8  1189.80n 0.8
+ 1190.00n 0.8  1199.80n 0.8
+ 1200.00n 0.8  1209.80n 0.8
+ 1210.00n 0.8  1219.80n 0.8
+ 1220.00n 0.8  1229.80n 0.8
+ 1230.00n 0.8  1239.80n 0.8
+ 1240.00n 0.8  1249.80n 0.8
+ 1250.00n 0  1259.80n 0
+ 1260.00n 0  1269.80n 0
+ 1270.00n 0  1279.80n 0
+ 1280.00n 0  1289.80n 0
+ 1290.00n 0  1299.80n 0
+ 1300.00n 0  1309.80n 0
+ 1310.00n 0  1319.80n 0
+ 1320.00n 0  1329.80n 0
+ 1330.00n 0  1339.80n 0
+ 1340.00n 0  1349.80n 0
+ 1350.00n 0  1359.80n 0
+ 1360.00n 0  1369.80n 0
+ 1370.00n 0  1379.80n 0
+ 1380.00n 0  1389.80n 0
+ 1390.00n 0  1399.80n 0
+ 1400.00n 0  1409.80n 0
+ 1410.00n 0  1419.80n 0
+ 1420.00n 0  1429.80n 0
+ 1430.00n 0  1439.80n 0
+ 1440.00n 0  1449.80n 0
+ 1450.00n 0  1459.80n 0
+ 1460.00n 0  1469.80n 0
+ 1470.00n 0  1479.80n 0
+ 1480.00n 0  1489.80n 0
+ 1490.00n 0  1499.80n 0
+ 1500.00n 0)
Vahi ahi 0 pwl(
+ 0.00n 0.4  9.80n 0.4
+ 10.00n 0.6  19.80n 0.6
+ 20.00n 0.8  29.80n 0.8
+ 30.00n 1.1  39.80n 1.1
+ 40.00n 1.3  49.80n 1.3
+ 50.00n 0.4  59.80n 0.4
+ 60.00n 0.6  69.80n 0.6
+ 70.00n 0.8  79.80n 0.8
+ 80.00n 1.1  89.80n 1.1
+ 90.00n 1.3  99.80n 1.3
+ 100.00n 0.4  109.80n 0.4
+ 110.00n 0.6  119.80n 0.6
+ 120.00n 0.8  129.80n 0.8
+ 130.00n 1.1  139.80n 1.1
+ 140.00n 1.3  149.80n 1.3
+ 150.00n 0.4  159.80n 0.4
+ 160.00n 0.6  169.80n 0.6
+ 170.00n 0.8  179.80n 0.8
+ 180.00n 1.1  189.80n 1.1
+ 190.00n 1.3  199.80n 1.3
+ 200.00n 0.4  209.80n 0.4
+ 210.00n 0.6  219.80n 0.6
+ 220.00n 0.8  229.80n 0.8
+ 230.00n 1.1  239.80n 1.1
+ 240.00n 1.3  249.80n 1.3
+ 250.00n 0.4  259.80n 0.4
+ 260.00n 0.6  269.80n 0.6
+ 270.00n 0.8  279.80n 0.8
+ 280.00n 1.1  289.80n 1.1
+ 290.00n 1.3  299.80n 1.3
+ 300.00n 0.4  309.80n 0.4
+ 310.00n 0.6  319.80n 0.6
+ 320.00n 0.8  329.80n 0.8
+ 330.00n 1.1  339.80n 1.1
+ 340.00n 1.3  349.80n 1.3
+ 350.00n 0.4  359.80n 0.4
+ 360.00n 0.6  369.80n 0.6
+ 370.00n 0.8  379.80n 0.8
+ 380.00n 1.1  389.80n 1.1
+ 390.00n 1.3  399.80n 1.3
+ 400.00n 0.4  409.80n 0.4
+ 410.00n 0.6  419.80n 0.6
+ 420.00n 0.8  429.80n 0.8
+ 430.00n 1.1  439.80n 1.1
+ 440.00n 1.3  449.80n 1.3
+ 450.00n 0.4  459.80n 0.4
+ 460.00n 0.6  469.80n 0.6
+ 470.00n 0.8  479.80n 0.8
+ 480.00n 1.1  489.80n 1.1
+ 490.00n 1.3  499.80n 1.3
+ 500.00n 0.4  509.80n 0.4
+ 510.00n 0.6  519.80n 0.6
+ 520.00n 0.8  529.80n 0.8
+ 530.00n 1.1  539.80n 1.1
+ 540.00n 1.3  549.80n 1.3
+ 550.00n 0.4  559.80n 0.4
+ 560.00n 0.6  569.80n 0.6
+ 570.00n 0.8  579.80n 0.8
+ 580.00n 1.1  589.80n 1.1
+ 590.00n 1.3  599.80n 1.3
+ 600.00n 0.4  609.80n 0.4
+ 610.00n 0.6  619.80n 0.6
+ 620.00n 0.8  629.80n 0.8
+ 630.00n 1.1  639.80n 1.1
+ 640.00n 1.3  649.80n 1.3
+ 650.00n 0.4  659.80n 0.4
+ 660.00n 0.6  669.80n 0.6
+ 670.00n 0.8  679.80n 0.8
+ 680.00n 1.1  689.80n 1.1
+ 690.00n 1.3  699.80n 1.3
+ 700.00n 0.4  709.80n 0.4
+ 710.00n 0.6  719.80n 0.6
+ 720.00n 0.8  729.80n 0.8
+ 730.00n 1.1  739.80n 1.1
+ 740.00n 1.3  749.80n 1.3
+ 750.00n 0.4  759.80n 0.4
+ 760.00n 0.6  769.80n 0.6
+ 770.00n 0.8  779.80n 0.8
+ 780.00n 1.1  789.80n 1.1
+ 790.00n 1.3  799.80n 1.3
+ 800.00n 0.4  809.80n 0.4
+ 810.00n 0.6  819.80n 0.6
+ 820.00n 0.8  829.80n 0.8
+ 830.00n 1.1  839.80n 1.1
+ 840.00n 1.3  849.80n 1.3
+ 850.00n 0.4  859.80n 0.4
+ 860.00n 0.6  869.80n 0.6
+ 870.00n 0.8  879.80n 0.8
+ 880.00n 1.1  889.80n 1.1
+ 890.00n 1.3  899.80n 1.3
+ 900.00n 0.4  909.80n 0.4
+ 910.00n 0.6  919.80n 0.6
+ 920.00n 0.8  929.80n 0.8
+ 930.00n 1.1  939.80n 1.1
+ 940.00n 1.3  949.80n 1.3
+ 950.00n 0.4  959.80n 0.4
+ 960.00n 0.6  969.80n 0.6
+ 970.00n 0.8  979.80n 0.8
+ 980.00n 1.1  989.80n 1.1
+ 990.00n 1.3  999.80n 1.3
+ 1000.00n 0.4  1009.80n 0.4
+ 1010.00n 0.6  1019.80n 0.6
+ 1020.00n 0.8  1029.80n 0.8
+ 1030.00n 1.1  1039.80n 1.1
+ 1040.00n 1.3  1049.80n 1.3
+ 1050.00n 0.4  1059.80n 0.4
+ 1060.00n 0.6  1069.80n 0.6
+ 1070.00n 0.8  1079.80n 0.8
+ 1080.00n 1.1  1089.80n 1.1
+ 1090.00n 1.3  1099.80n 1.3
+ 1100.00n 0.4  1109.80n 0.4
+ 1110.00n 0.6  1119.80n 0.6
+ 1120.00n 0.8  1129.80n 0.8
+ 1130.00n 1.1  1139.80n 1.1
+ 1140.00n 1.3  1149.80n 1.3
+ 1150.00n 0.4  1159.80n 0.4
+ 1160.00n 0.6  1169.80n 0.6
+ 1170.00n 0.8  1179.80n 0.8
+ 1180.00n 1.1  1189.80n 1.1
+ 1190.00n 1.3  1199.80n 1.3
+ 1200.00n 0.4  1209.80n 0.4
+ 1210.00n 0.6  1219.80n 0.6
+ 1220.00n 0.8  1229.80n 0.8
+ 1230.00n 1.1  1239.80n 1.1
+ 1240.00n 1.3  1249.80n 1.3
+ 1250.00n 0.4  1259.80n 0.4
+ 1260.00n 0.6  1269.80n 0.6
+ 1270.00n 0.8  1279.80n 0.8
+ 1280.00n 1.1  1289.80n 1.1
+ 1290.00n 1.3  1299.80n 1.3
+ 1300.00n 0.4  1309.80n 0.4
+ 1310.00n 0.6  1319.80n 0.6
+ 1320.00n 0.8  1329.80n 0.8
+ 1330.00n 1.1  1339.80n 1.1
+ 1340.00n 1.3  1349.80n 1.3
+ 1350.00n 0.4  1359.80n 0.4
+ 1360.00n 0.6  1369.80n 0.6
+ 1370.00n 0.8  1379.80n 0.8
+ 1380.00n 1.1  1389.80n 1.1
+ 1390.00n 1.3  1399.80n 1.3
+ 1400.00n 0.4  1409.80n 0.4
+ 1410.00n 0.6  1419.80n 0.6
+ 1420.00n 0.8  1429.80n 0.8
+ 1430.00n 1.1  1439.80n 1.1
+ 1440.00n 1.3  1449.80n 1.3
+ 1450.00n 0.4  1459.80n 0.4
+ 1460.00n 0.6  1469.80n 0.6
+ 1470.00n 0.8  1479.80n 0.8
+ 1480.00n 1.1  1489.80n 1.1
+ 1490.00n 1.3  1499.80n 1.3
+ 1500.00n 1.3)
Valo alo 0 0.0

* Padrao 00 (A=0, AN=Vin, B=0, BN=Vin)
X00_1 out00 ahi rtop alo gtop ARI W=1.0
X00_2 out00 alo rtop ahi gtop ARI W=1.0
X00_3 out00 alo rbot alo gbot ARI W=1.0
X00_4 out00 ahi rbot ahi gbot ARI W=1.0
C00 out00 0 0.2f

* Padrao 01 (A=0, AN=Vin, B=Vin, BN=0)
X01_1 out01 ahi rtop ahi gtop ARI W=1.0
X01_2 out01 alo rtop alo gtop ARI W=1.0
X01_3 out01 alo rbot ahi gbot ARI W=1.0
X01_4 out01 ahi rbot alo gbot ARI W=1.0
C01 out01 0 0.2f

* Padrao 10 (A=Vin, AN=0, B=0, BN=Vin)
X10_1 out10 alo rtop alo gtop ARI W=1.0
X10_2 out10 ahi rtop ahi gtop ARI W=1.0
X10_3 out10 ahi rbot alo gbot ARI W=1.0
X10_4 out10 alo rbot ahi gbot ARI W=1.0
C10 out10 0 0.2f

* Padrao 11 (A=Vin, AN=0, B=Vin, BN=0)
X11_1 out11 alo rtop ahi gtop ARI W=1.0
X11_2 out11 ahi rtop alo gtop ARI W=1.0
X11_3 out11 ahi rbot ahi gbot ARI W=1.0
X11_4 out11 alo rbot alo gbot ARI W=1.0
C11 out11 0 0.2f

.control
set wr_vecnames
set wr_singlescale
tran 100p 1500.0n
wrdata sweep_xor_xnor_vdd_vin.dat v(out00) v(out01) v(out10) v(out11) i(Vrtop) i(Vrbot)
.endc
.end
